// Copyright lowRISC contributors (OpenTitan project).
// Licensed under the Apache License, Version 2.0, see LICENSE for details.
// SPDX-License-Identifier: Apache-2.0
{
  name: "pinmux_fpv"
  // The requirements of the pinmux FPV testplan (doc/fpv/README.md), one entry each:
  //   name, desc   the requirement ID and its statement
  //   source      where the rule comes from: !!REGISTER.FIELD names a register field
  //               (reggen's form), a Markdown link names a document section or a key
  //   kind        "spec": a specification states the rule; "RTL": none does, and the
  //               rule follows the design's present behaviour or leaves the outcome
  //               to a specification question
  //   testpoint   its testpoint in pinmux_env_fpv_testplan.hjson
  //   checks      what decides it: "<check name> (<planned assertion>)", the CSR
  //               checker, another testbench, or a check out of scope or waiting
  //   why         why those checks prove it
  //   milestone   the verification stage of its testpoint: V1, V2 or V2S
  //   priority    the order of work within a stage: "1" before "2"
  //   security    true when a security property depends on it
  //   state       "open" until its checks are proven; with a reason where no check
  //               of this plan decides it
  // The file holds, besides the entries:
  //   written_for   the top the plan was written for and read against
  //   rendered_for  the top of this copy; other tops render it from the same
  //                 template with their own parameters, and their requirements
  //                 are not reviewed
  //   terms         the words the requirements use, each with its meaning
  //   groups        the requirements by feature; a group's conditions say when
  //                 its requirements hold and define its own words
  written_for: "earlgrey"
  rendered_for: "earlgrey"
  terms: [
    {
      name: '''`n`'''
      desc: '''MIO peripheral input (0 to 93)'''
    }
    {
      name: '''`k`'''
      desc: '''MIO peripheral output (0 to 103)'''
    }
    {
      name: '''`p`'''
      desc: '''MIO pad (0 to 46)'''
    }
    {
      name: '''`d`'''
      desc: '''DIO pad (0 to 15)'''
    }
    {
      name: '''Watched signal'''
      desc: '''The pad input that `MIODIO` and `PADSEL` pick'''
    }
    {
      name: '''Forwarded value'''
      desc: '''The watched signal sampled each `clk_aon_i` cycle, through the filter when `FILTER` is 1'''
    }
    {
      name: '''Asleep, awake'''
      desc: '''A pad is asleep while its sleep status bit is 1, awake while it is 0'''
    }
    {
      name: '''AON'''
      desc: '''The always-on domain: the logic on `clk_aon_i` and `rst_aon_ni`'''
    }
    {
      name: '''Lands'''
      desc: '''A written or sampled value lands in the cycle the register or flop it is meant for takes it'''
    }
    {
      name: '''Hardware write'''
      desc: '''A write to a register field made by the pinmux logic, not by software over the bus'''
    }
    {
      name: '''Full reset'''
      desc: '''A reset that asserts `rst_sys_ni`, which the top connects to the system reset tree ([top_earlgrey.hjson `module.pinmux`](hw/top_earlgrey/data/top_earlgrey.hjson))'''
    }
    {
      name: '''NDM reset'''
      desc: '''A reset that asserts `rst_ni` and `rst_aon_ni`, not `rst_sys_ni`: the top connects those two to the life cycle reset tree ([top_earlgrey.hjson `module.pinmux`](hw/top_earlgrey/data/top_earlgrey.hjson)), the tree a non-debug module reset request asserts outside PROD and PROD_END ([Summary](hw/top_earlgrey/ip_autogen/rstmgr/doc/theory_of_operation.md#summary)); what is on `rst_sys_ni` survives it ([Non-debug Module Reset](hw/top_earlgrey/ip_autogen/pinmux/doc/theory_of_operation.md#non-debug-module-reset))'''
    }
    {
      name: '''On, Off'''
      desc: '''On is 4'b0101 and Off 4'b1010, the life cycle controller's values ([Control Signal Propagation](hw/ip/lc_ctrl/doc/interfaces.md#control-signal-propagation))'''
    }
    {
      name: '''The latch'''
      desc: '''The latched debug enable, seen on `pinmux_hw_debug_en_o` and through the RISC-V TAP'''
    }
    {
      name: '''A clear'''
      desc: '''`lc_hw_debug_clr_i`, `lc_check_byp_en_i` or `lc_escalate_en_i` at any value other than Off ([Non-debug Module Reset](hw/top_earlgrey/ip_autogen/pinmux/doc/theory_of_operation.md#non-debug-module-reset); [Control Signal Propagation](hw/ip/lc_ctrl/doc/interfaces.md#control-signal-propagation) for the debug clear and the escalation input); it turns the latch Off'''
    }
    {
      name: '''Connected'''
      desc: '''A TAP is connected while the TAP straps name it and its gate is open: the life cycle TAP at straps 01; the RISC-V TAP at straps 10 while the latch is On; the DFT TAP at straps 11 while `lc_dft_en_i` is On; on a top with the RRAM TAP (`enable_rram_tap`), the RRAM TAP at straps 00 while `RRAM_JTAG_SEL` is `kMultiBitBool4True` and `lc_nvm_debug_en_i` is On; at straps 00, no TAP otherwise ([Strap Sampling and TAP Isolation](hw/top_earlgrey/ip_autogen/pinmux/doc/theory_of_operation.md#strap-sampling-and-tap-isolation), [Non-debug Module Reset](hw/top_earlgrey/ip_autogen/pinmux/doc/theory_of_operation.md#non-debug-module-reset))'''
    }
    {
      name: '''Owns'''
      desc: '''A TAP owns the JTAG pads while it is connected: the pads then carry the TAP's signals, not what the pad muxes select'''
    }
    {
      name: '''Cut'''
      desc: '''A TAP is cut while its gate is shut, or while the TAP straps name another TAP or none'''
    }
    {
      name: '''Allowed pad'''
      desc: '''For a signal: its `pads` list names the pad, or the list is empty'''
    }
    {
      name: '''Main pad'''
      desc: '''A pad of bank VIOA or VIOB: IOA, IOB and the SPI pads, 34 of 61'''
    }
    {
      name: '''Main off'''
      desc: '''The Main section's reset with the AON resets high. A Main peripheral's input then has no requirement, as that peripheral is off.'''
    }
  ]
  groups: [
    {
      name: '''Input selection'''
      conditions: [
        '''every row holds in every cycle, except for a JTAG pad while a TAP owns it.'''
      ]
      requirements: [
        {
          name: REQ_IN_01
          desc: '''MIO peripheral input `n` shall read 0 while `MIO_PERIPH_INSEL_n` is 0.'''
          source: [
            '''!!MIO_PERIPH_INSEL.IN'''
          ]
          kind: "spec"
          testpoint: "pad_listen"
          checks: ["reads tie 0 (assert_PadListen_ReadsTie0)"]
          why: '''In every cycle the check compares each MIO peripheral input whose select is 0 with 0.'''
          milestone: "V1"
          priority: "1"
          security: false
          state: "open"
        }
        {
          name: REQ_IN_02
          desc: '''MIO peripheral input `n` shall read 1 while `MIO_PERIPH_INSEL_n` is 1.'''
          source: [
            '''!!MIO_PERIPH_INSEL.IN'''
          ]
          kind: "spec"
          testpoint: "pad_listen"
          checks: ["reads tie 1 (assert_PadListen_ReadsTie1)"]
          why: '''In every cycle the check compares each MIO peripheral input whose select is 1 with 1.'''
          milestone: "V1"
          priority: "1"
          security: false
          state: "open"
        }
        {
          name: REQ_IN_03
          desc: '''MIO peripheral input `n` shall read the input of MIO pad `p`, in the same cycle, while `MIO_PERIPH_INSEL_n` is 2 + `p` (`p` from 0 to 46).'''
          source: [
            '''!!MIO_PERIPH_INSEL.IN'''
            '''[top_earlgrey_pinmux.ipconfig.hjson `n_mio_pads`](hw/top_earlgrey/ip_autogen/pinmux/data/top_earlgrey_pinmux.ipconfig.hjson)'''
          ]
          kind: "spec"
          testpoint: "pad_listen"
          checks: ["reads selected pad (assert_PadListen_ReadsSelectedPad)"]
          why: '''For each select from 2 to 48 the check compares the input with `mio_in_i` of pad select minus 2, in the same cycle.'''
          milestone: "V1"
          priority: "1"
          security: false
          state: "open"
        }
        {
          name: REQ_IN_04
          desc: '''MIO peripheral input `n` shall read 0 while `MIO_PERIPH_INSEL_n` is 49 to 63, the values that name no pad.'''
          source: [
            '''!!MIO_PERIPH_INSEL'''
            '''[top_earlgrey_pinmux.ipconfig.hjson `n_mio_pads`](hw/top_earlgrey/ip_autogen/pinmux/data/top_earlgrey_pinmux.ipconfig.hjson)'''
          ]
          kind: "RTL"
          testpoint: "pad_listen"
          checks: ["no pad reads 0 (assert_PadListen_NoPadReads0)"]
          why: '''For selects 49 to 63, which name no pad, the check compares the input with 0.'''
          milestone: "V1"
          priority: "1"
          security: false
          state: "open"
        }
        {
          name: REQ_IN_05
          desc: '''DIO peripheral input `d` shall read the input of DIO pad `d`, in the same cycle, whatever the registers hold.'''
          source: [
            '''[MIO and DIO Signal Categories](hw/top_earlgrey/ip_autogen/pinmux/doc/theory_of_operation.md#mio-and-dio-signal-categories)'''
          ]
          kind: "spec"
          testpoint: "pad_listen"
          checks: ["DIO reads its pad (assert_PadListen_DioReadsItsPad)"]
          why: '''The check compares each DIO peripheral input with its own pad's `dio_in_i` in the same cycle, whatever the registers hold.'''
          milestone: "V1"
          priority: "1"
          security: false
          state: "open"
        }
        {
          name: REQ_IN_06
          desc: '''After reset, every MIO peripheral input shall read 0 until software writes its select.'''
          source: [
            '''[Pinmux Configuration](hw/top_earlgrey/ip_autogen/pinmux/doc/programmers_guide.md#pinmux-configuration)'''
            '''[MIO and DIO Signal Categories](hw/top_earlgrey/ip_autogen/pinmux/doc/theory_of_operation.md#mio-and-dio-signal-categories)'''
            '''!!MIO_PERIPH_INSEL.IN'''
          ]
          kind: "spec"
          testpoint: "reset_state"
          checks: ["reads tie 0 (assert_PadListen_ReadsTie0)", "the CSR checker"]
          why: '''The CSR checker keeps each input select at 0 until written, and _reads tie 0_ makes such an input read 0.'''
          milestone: "V2"
          priority: "2"
          security: false
          state: "open"
        }
      ]
    }
    {
      name: '''Output selection'''
      conditions: [
        '''every row holds while the pad's sleep mode is not active (Sleep retention) and no TAP owns the pad.'''
      ]
      requirements: [
        {
          name: REQ_OUT_01a
          desc: '''The output of MIO pad `p` shall be 0 while `MIO_OUTSEL_p` is 0.'''
          source: [
            '''!!MIO_OUTSEL.OUT'''
          ]
          kind: "spec"
          testpoint: "pad_output"
          checks: ["tie 0 drives 0 (assert_PadOutput_Tie0Drives0)"]
          why: '''While an awake pad's select is 0, the check compares the pad's output with 0 in every cycle.'''
          milestone: "V1"
          priority: "1"
          security: false
          state: "open"
        }
        {
          name: REQ_OUT_01b
          desc: '''The output enable of MIO pad `p` shall be 1 while `MIO_OUTSEL_p` is 0, so the pad drives 0.'''
          source: [
            '''!!MIO_OUTSEL.OUT'''
          ]
          kind: "spec"
          testpoint: "pad_output"
          checks: ["tie 0 drives 0 (assert_PadOutput_Tie0Drives0)"]
          why: '''Under select 0 the check compares the pad's output enable with 1 in every cycle.'''
          milestone: "V1"
          priority: "1"
          security: false
          state: "open"
        }
        {
          name: REQ_OUT_02a
          desc: '''The output of MIO pad `p` shall be 1 while `MIO_OUTSEL_p` is 1.'''
          source: [
            '''!!MIO_OUTSEL.OUT'''
          ]
          kind: "spec"
          testpoint: "pad_output"
          checks: ["tie 1 drives 1 (assert_PadOutput_Tie1Drives1)"]
          why: '''While an awake pad's select is 1, the check compares the pad's output with 1 in every cycle.'''
          milestone: "V1"
          priority: "1"
          security: false
          state: "open"
        }
        {
          name: REQ_OUT_02b
          desc: '''The output enable of MIO pad `p` shall be 1 while `MIO_OUTSEL_p` is 1, so the pad drives 1.'''
          source: [
            '''!!MIO_OUTSEL.OUT'''
          ]
          kind: "spec"
          testpoint: "pad_output"
          checks: ["tie 1 drives 1 (assert_PadOutput_Tie1Drives1)"]
          why: '''Under select 1 the check compares the pad's output enable with 1 in every cycle.'''
          milestone: "V1"
          priority: "1"
          security: false
          state: "open"
        }
        {
          name: REQ_OUT_03a
          desc: '''The output enable of MIO pad `p` shall be 0 while `MIO_OUTSEL_p` is 2: the pad is high-Z.'''
          source: [
            '''!!MIO_OUTSEL.OUT'''
          ]
          kind: "spec"
          testpoint: "pad_output"
          checks: ["select 2 is high-Z (assert_PadOutput_Select2IsHighZ)"]
          why: '''While an awake pad's select is 2, the check compares the pad's output enable with 0 in every cycle.'''
          milestone: "V1"
          priority: "1"
          security: false
          state: "open"
        }
        {
          name: REQ_OUT_03b
          desc: '''The output of MIO pad `p` shall be 0 while `MIO_OUTSEL_p` is 2.'''
          source: [
            '''!!MIO_OUTSEL.OUT'''
          ]
          kind: "spec"
          testpoint: "pad_output"
          checks: ["select 2 is high-Z (assert_PadOutput_Select2IsHighZ)"]
          why: '''Under select 2 the check compares the pad's output with 0 in every cycle.'''
          milestone: "V1"
          priority: "1"
          security: false
          state: "open"
        }
        {
          name: REQ_OUT_04a
          desc: '''MIO pad `p` shall carry peripheral output `k`, in the same cycle, while `MIO_OUTSEL_p` is 3 + `k` (`k` from 0 to 103).'''
          source: [
            '''!!MIO_OUTSEL.OUT'''
            '''[Muxing Matrix](hw/top_earlgrey/ip_autogen/pinmux/doc/theory_of_operation.md#muxing-matrix)'''
            '''[top_earlgrey_pinmux.ipconfig.hjson `n_mio_periph_out`](hw/top_earlgrey/ip_autogen/pinmux/data/top_earlgrey_pinmux.ipconfig.hjson)'''
          ]
          kind: "spec"
          testpoint: "pad_output"
          checks: ["drives selected output (assert_PadOutput_DrivesSelectedOutput)"]
          why: '''For each select from 3 to 106 the check compares the pad's output with `periph_to_mio_i[k]`, `k` the select minus 3, in the same cycle.'''
          milestone: "V1"
          priority: "1"
          security: false
          state: "open"
        }
        {
          name: REQ_OUT_04b
          desc: '''MIO pad `p` shall carry output enable `k`, in the same cycle, while `MIO_OUTSEL_p` is 3 + `k` (`k` from 0 to 103).'''
          source: [
            '''!!MIO_OUTSEL.OUT'''
            '''[Muxing Matrix](hw/top_earlgrey/ip_autogen/pinmux/doc/theory_of_operation.md#muxing-matrix)'''
            '''[top_earlgrey_pinmux.ipconfig.hjson `n_mio_periph_out`](hw/top_earlgrey/ip_autogen/pinmux/data/top_earlgrey_pinmux.ipconfig.hjson)'''
          ]
          kind: "spec"
          testpoint: "pad_output"
          checks: ["drives selected output (assert_PadOutput_DrivesSelectedOutput)"]
          why: '''The check compares the pad's output enable with `periph_to_mio_oe_i[k]`, `k` as for the data, in the same cycle.'''
          milestone: "V1"
          priority: "1"
          security: false
          state: "open"
        }
        {
          name: REQ_OUT_05a
          desc: '''The output enable of MIO pad `p` shall be 0 while `MIO_OUTSEL_p` is 107 to 127, the values that name no peripheral output: the pad is high-Z.'''
          source: [
            '''!!MIO_OUTSEL'''
            '''[top_earlgrey_pinmux.ipconfig.hjson `n_mio_periph_out`](hw/top_earlgrey/ip_autogen/pinmux/data/top_earlgrey_pinmux.ipconfig.hjson)'''
          ]
          kind: "RTL"
          testpoint: "pad_output"
          checks: ["no output is high-Z (assert_PadOutput_NoOutputIsHighZ)"]
          why: '''For selects 107 to 127, which name no output, the check compares the pad's output enable with 0.'''
          milestone: "V1"
          priority: "1"
          security: false
          state: "open"
        }
        {
          name: REQ_OUT_05b
          desc: '''The output of MIO pad `p` shall be 0 while `MIO_OUTSEL_p` is 107 to 127, the values that name no peripheral output.'''
          source: [
            '''!!MIO_OUTSEL'''
            '''[top_earlgrey_pinmux.ipconfig.hjson `n_mio_periph_out`](hw/top_earlgrey/ip_autogen/pinmux/data/top_earlgrey_pinmux.ipconfig.hjson)'''
          ]
          kind: "RTL"
          testpoint: "pad_output"
          checks: ["no output is high-Z (assert_PadOutput_NoOutputIsHighZ)"]
          why: '''For selects 107 to 127 the check compares the pad's output with 0.'''
          milestone: "V1"
          priority: "1"
          security: false
          state: "open"
        }
        {
          name: REQ_OUT_06a
          desc: '''DIO pad `d` shall carry its peripheral's output, in the same cycle.'''
          source: [
            '''[MIO and DIO Signal Categories](hw/top_earlgrey/ip_autogen/pinmux/doc/theory_of_operation.md#mio-and-dio-signal-categories)'''
          ]
          kind: "spec"
          testpoint: "pad_output"
          checks: ["DIO drives its peripheral (assert_PadOutput_DioDrivesItsPeripheral)"]
          why: '''The check compares each awake DIO pad's output with `periph_to_dio_i[d]` in the same cycle, whatever the registers hold.'''
          milestone: "V1"
          priority: "1"
          security: false
          state: "open"
        }
        {
          name: REQ_OUT_06b
          desc: '''DIO pad `d` shall carry its peripheral's output enable, in the same cycle.'''
          source: [
            '''[MIO and DIO Signal Categories](hw/top_earlgrey/ip_autogen/pinmux/doc/theory_of_operation.md#mio-and-dio-signal-categories)'''
          ]
          kind: "spec"
          testpoint: "pad_output"
          checks: ["DIO drives its peripheral (assert_PadOutput_DioDrivesItsPeripheral)"]
          why: '''The check compares each awake DIO pad's output enable with `periph_to_dio_oe_i[d]` in the same cycle, whatever the registers hold.'''
          milestone: "V1"
          priority: "1"
          security: false
          state: "open"
        }
        {
          name: REQ_OUT_07
          desc: '''After reset, every MIO pad shall be high-Z until software writes its select.'''
          source: [
            '''[MIO and DIO Signal Categories](hw/top_earlgrey/ip_autogen/pinmux/doc/theory_of_operation.md#mio-and-dio-signal-categories)'''
            '''[Pinmux Configuration](hw/top_earlgrey/ip_autogen/pinmux/doc/programmers_guide.md#pinmux-configuration)'''
            '''!!MIO_OUTSEL.OUT'''
          ]
          kind: "spec"
          testpoint: "reset_state"
          checks: ["select 2 is high-Z (assert_PadOutput_Select2IsHighZ)", "the CSR checker"]
          why: '''The CSR checker keeps each output select at 2 until written; _select 2 is high-Z_ then makes an awake pad high-Z.'''
          milestone: "V2"
          priority: "2"
          security: false
          state: "open"
        }
      ]
    }
    {
      name: '''Pad attributes'''
      conditions: [
        '''every row holds in every cycle, asleep or awake, except on a JTAG pad while a TAP owns it. "Written" means a write the register block accepts, its lock open (Register locks); "reads back" means what a read of the register returns. A pad type "keeps" an attribute bit when its pads implement that bit ([Pad Attributes](hw/top_earlgrey/ip_autogen/pinmux/doc/programmers_guide.md#pad-attributes)), the same on every pad of the type and for good. A one-bit field is kept when its bit is; each bit of `slew_rate` and `drive_strength` is kept or not on its own ([Pad Attributes](hw/top_earlgrey/ip_autogen/pinmux/doc/programmers_guide.md#pad-attributes)).'''
      ]
      requirements: [
        {
          name: REQ_ATTR_01a
          desc: '''The attribute output of MIO pad `p` shall equal, in field `invert`, what `MIO_PAD_ATTR_p` reads back.'''
          source: [
            '''!!MIO_PAD_ATTR.invert'''
            '''[Type RW HWExt](util/reggen/README.md#type-rw-hwext)'''
            '''[Generic Pad Wrapper](hw/top_earlgrey/ip_autogen/pinmux/doc/theory_of_operation.md#generic-pad-wrapper)'''
          ]
          kind: "spec"
          testpoint: "pad_attr"
          checks: ["pad gets read-back (assert_PadAttr_PadGetsReadBack)"]
          why: '''In every cycle the check compares field `invert` of the pad's `mio_attr_o` with the read-back of `MIO_PAD_ATTR_p`.'''
          milestone: "V2"
          priority: "2"
          security: false
          state: "open"
        }
        {
          name: REQ_ATTR_01b
          desc: '''The attribute output of MIO pad `p` shall equal, in field `virtual_od_en`, what `MIO_PAD_ATTR_p` reads back.'''
          source: [
            '''!!MIO_PAD_ATTR.virtual_od_en'''
            '''[Type RW HWExt](util/reggen/README.md#type-rw-hwext)'''
            '''[Generic Pad Wrapper](hw/top_earlgrey/ip_autogen/pinmux/doc/theory_of_operation.md#generic-pad-wrapper)'''
          ]
          kind: "spec"
          testpoint: "pad_attr"
          checks: ["pad gets read-back (assert_PadAttr_PadGetsReadBack)"]
          why: '''In every cycle the check compares field `virtual_od_en` of the pad's `mio_attr_o` with the read-back of `MIO_PAD_ATTR_p`.'''
          milestone: "V2"
          priority: "2"
          security: false
          state: "open"
        }
        {
          name: REQ_ATTR_01c
          desc: '''The attribute output of MIO pad `p` shall equal, in field `pull_en`, what `MIO_PAD_ATTR_p` reads back.'''
          source: [
            '''!!MIO_PAD_ATTR.pull_en'''
            '''[Type RW HWExt](util/reggen/README.md#type-rw-hwext)'''
            '''[Generic Pad Wrapper](hw/top_earlgrey/ip_autogen/pinmux/doc/theory_of_operation.md#generic-pad-wrapper)'''
          ]
          kind: "spec"
          testpoint: "pad_attr"
          checks: ["pad gets read-back (assert_PadAttr_PadGetsReadBack)"]
          why: '''In every cycle the check compares field `pull_en` of the pad's `mio_attr_o` with the read-back of `MIO_PAD_ATTR_p`.'''
          milestone: "V2"
          priority: "2"
          security: false
          state: "open"
        }
        {
          name: REQ_ATTR_01d
          desc: '''The attribute output of MIO pad `p` shall equal, in field `pull_select`, what `MIO_PAD_ATTR_p` reads back.'''
          source: [
            '''!!MIO_PAD_ATTR.pull_select'''
            '''[Type RW HWExt](util/reggen/README.md#type-rw-hwext)'''
            '''[Generic Pad Wrapper](hw/top_earlgrey/ip_autogen/pinmux/doc/theory_of_operation.md#generic-pad-wrapper)'''
          ]
          kind: "spec"
          testpoint: "pad_attr"
          checks: ["pad gets read-back (assert_PadAttr_PadGetsReadBack)"]
          why: '''In every cycle the check compares field `pull_select` of the pad's `mio_attr_o` with the same field of the read-back of `MIO_PAD_ATTR_p`.'''
          milestone: "V2"
          priority: "2"
          security: false
          state: "open"
        }
        {
          name: REQ_ATTR_01e
          desc: '''The attribute output of MIO pad `p` shall equal, in field `keeper_en`, what `MIO_PAD_ATTR_p` reads back.'''
          source: [
            '''!!MIO_PAD_ATTR.keeper_en'''
            '''[Type RW HWExt](util/reggen/README.md#type-rw-hwext)'''
            '''[Generic Pad Wrapper](hw/top_earlgrey/ip_autogen/pinmux/doc/theory_of_operation.md#generic-pad-wrapper)'''
          ]
          kind: "spec"
          testpoint: "pad_attr"
          checks: ["pad gets read-back (assert_PadAttr_PadGetsReadBack)"]
          why: '''In every cycle the check compares field `keeper_en` of the pad's `mio_attr_o` with the read-back of `MIO_PAD_ATTR_p`.'''
          milestone: "V2"
          priority: "2"
          security: false
          state: "open"
        }
        {
          name: REQ_ATTR_01f
          desc: '''The attribute output of MIO pad `p` shall equal, in field `schmitt_en`, what `MIO_PAD_ATTR_p` reads back.'''
          source: [
            '''!!MIO_PAD_ATTR.schmitt_en'''
            '''[Type RW HWExt](util/reggen/README.md#type-rw-hwext)'''
            '''[Generic Pad Wrapper](hw/top_earlgrey/ip_autogen/pinmux/doc/theory_of_operation.md#generic-pad-wrapper)'''
          ]
          kind: "spec"
          testpoint: "pad_attr"
          checks: ["pad gets read-back (assert_PadAttr_PadGetsReadBack)"]
          why: '''In every cycle the check compares field `schmitt_en` of the pad's `mio_attr_o` with the same field of the read-back of `MIO_PAD_ATTR_p`.'''
          milestone: "V2"
          priority: "2"
          security: false
          state: "open"
        }
        {
          name: REQ_ATTR_01g
          desc: '''The attribute output of MIO pad `p` shall equal, in field `od_en`, what `MIO_PAD_ATTR_p` reads back.'''
          source: [
            '''!!MIO_PAD_ATTR.od_en'''
            '''[Type RW HWExt](util/reggen/README.md#type-rw-hwext)'''
            '''[Generic Pad Wrapper](hw/top_earlgrey/ip_autogen/pinmux/doc/theory_of_operation.md#generic-pad-wrapper)'''
          ]
          kind: "spec"
          testpoint: "pad_attr"
          checks: ["pad gets read-back (assert_PadAttr_PadGetsReadBack)"]
          why: '''In every cycle the check compares field `od_en` of the pad's `mio_attr_o` with the read-back of `MIO_PAD_ATTR_p`.'''
          milestone: "V2"
          priority: "2"
          security: false
          state: "open"
        }
        {
          name: REQ_ATTR_01h
          desc: '''The attribute output of MIO pad `p` shall equal, in field `input_disable`, what `MIO_PAD_ATTR_p` reads back.'''
          source: [
            '''!!MIO_PAD_ATTR.input_disable'''
            '''[Type RW HWExt](util/reggen/README.md#type-rw-hwext)'''
            '''[Generic Pad Wrapper](hw/top_earlgrey/ip_autogen/pinmux/doc/theory_of_operation.md#generic-pad-wrapper)'''
          ]
          kind: "spec"
          testpoint: "pad_attr"
          checks: ["pad gets read-back (assert_PadAttr_PadGetsReadBack)"]
          why: '''In every cycle the check compares field `input_disable` of the pad's `mio_attr_o` with the read-back of `MIO_PAD_ATTR_p`.'''
          milestone: "V2"
          priority: "2"
          security: false
          state: "open"
        }
        {
          name: REQ_ATTR_01i
          desc: '''The attribute output of MIO pad `p` shall equal, in field `slew_rate`, what `MIO_PAD_ATTR_p` reads back.'''
          source: [
            '''!!MIO_PAD_ATTR.slew_rate'''
            '''[Type RW HWExt](util/reggen/README.md#type-rw-hwext)'''
            '''[Generic Pad Wrapper](hw/top_earlgrey/ip_autogen/pinmux/doc/theory_of_operation.md#generic-pad-wrapper)'''
          ]
          kind: "spec"
          testpoint: "pad_attr"
          checks: ["pad gets read-back (assert_PadAttr_PadGetsReadBack)"]
          why: '''In every cycle the check compares both bits of field `slew_rate` of the pad's `mio_attr_o` with the read-back of `MIO_PAD_ATTR_p`.'''
          milestone: "V2"
          priority: "2"
          security: false
          state: "open"
        }
        {
          name: REQ_ATTR_01j
          desc: '''The attribute output of MIO pad `p` shall equal, in field `drive_strength`, what `MIO_PAD_ATTR_p` reads back.'''
          source: [
            '''!!MIO_PAD_ATTR.drive_strength'''
            '''[Type RW HWExt](util/reggen/README.md#type-rw-hwext)'''
            '''[Generic Pad Wrapper](hw/top_earlgrey/ip_autogen/pinmux/doc/theory_of_operation.md#generic-pad-wrapper)'''
          ]
          kind: "spec"
          testpoint: "pad_attr"
          checks: ["pad gets read-back (assert_PadAttr_PadGetsReadBack)"]
          why: '''In every cycle the check compares the four bits of field `drive_strength` of the pad's `mio_attr_o` with the read-back of `MIO_PAD_ATTR_p`.'''
          milestone: "V2"
          priority: "2"
          security: false
          state: "open"
        }
        {
          name: REQ_ATTR_02a
          desc: '''The attribute output of DIO pad `d` shall equal, in field `invert`, what `DIO_PAD_ATTR_d` reads back.'''
          source: [
            '''!!DIO_PAD_ATTR.invert'''
            '''[Type RW HWExt](util/reggen/README.md#type-rw-hwext)'''
            '''[Generic Pad Wrapper](hw/top_earlgrey/ip_autogen/pinmux/doc/theory_of_operation.md#generic-pad-wrapper)'''
          ]
          kind: "spec"
          testpoint: "pad_attr"
          checks: ["pad gets read-back (assert_PadAttr_PadGetsReadBack)"]
          why: '''In every cycle the check compares field `invert` of the pad's `dio_attr_o` with the read-back of `DIO_PAD_ATTR_d`.'''
          milestone: "V2"
          priority: "2"
          security: false
          state: "open"
        }
        {
          name: REQ_ATTR_02b
          desc: '''The attribute output of DIO pad `d` shall equal, in field `virtual_od_en`, what `DIO_PAD_ATTR_d` reads back.'''
          source: [
            '''!!DIO_PAD_ATTR.virtual_od_en'''
            '''[Type RW HWExt](util/reggen/README.md#type-rw-hwext)'''
            '''[Generic Pad Wrapper](hw/top_earlgrey/ip_autogen/pinmux/doc/theory_of_operation.md#generic-pad-wrapper)'''
          ]
          kind: "spec"
          testpoint: "pad_attr"
          checks: ["pad gets read-back (assert_PadAttr_PadGetsReadBack)"]
          why: '''In every cycle the check compares field `virtual_od_en` of the pad's `dio_attr_o` with the read-back of `DIO_PAD_ATTR_d`.'''
          milestone: "V2"
          priority: "2"
          security: false
          state: "open"
        }
        {
          name: REQ_ATTR_02c
          desc: '''The attribute output of DIO pad `d` shall equal, in field `pull_en`, what `DIO_PAD_ATTR_d` reads back.'''
          source: [
            '''!!DIO_PAD_ATTR.pull_en'''
            '''[Type RW HWExt](util/reggen/README.md#type-rw-hwext)'''
            '''[Generic Pad Wrapper](hw/top_earlgrey/ip_autogen/pinmux/doc/theory_of_operation.md#generic-pad-wrapper)'''
          ]
          kind: "spec"
          testpoint: "pad_attr"
          checks: ["pad gets read-back (assert_PadAttr_PadGetsReadBack)"]
          why: '''In every cycle the check compares field `pull_en` of the pad's `dio_attr_o` with the read-back of `DIO_PAD_ATTR_d`.'''
          milestone: "V2"
          priority: "2"
          security: false
          state: "open"
        }
        {
          name: REQ_ATTR_02d
          desc: '''The attribute output of DIO pad `d` shall equal, in field `pull_select`, what `DIO_PAD_ATTR_d` reads back.'''
          source: [
            '''!!DIO_PAD_ATTR.pull_select'''
            '''[Type RW HWExt](util/reggen/README.md#type-rw-hwext)'''
            '''[Generic Pad Wrapper](hw/top_earlgrey/ip_autogen/pinmux/doc/theory_of_operation.md#generic-pad-wrapper)'''
          ]
          kind: "spec"
          testpoint: "pad_attr"
          checks: ["pad gets read-back (assert_PadAttr_PadGetsReadBack)"]
          why: '''In every cycle the check compares field `pull_select` of the pad's `dio_attr_o` with the same field of the read-back of `DIO_PAD_ATTR_d`.'''
          milestone: "V2"
          priority: "2"
          security: false
          state: "open"
        }
        {
          name: REQ_ATTR_02e
          desc: '''The attribute output of DIO pad `d` shall equal, in field `keeper_en`, what `DIO_PAD_ATTR_d` reads back.'''
          source: [
            '''!!DIO_PAD_ATTR.keeper_en'''
            '''[Type RW HWExt](util/reggen/README.md#type-rw-hwext)'''
            '''[Generic Pad Wrapper](hw/top_earlgrey/ip_autogen/pinmux/doc/theory_of_operation.md#generic-pad-wrapper)'''
          ]
          kind: "spec"
          testpoint: "pad_attr"
          checks: ["pad gets read-back (assert_PadAttr_PadGetsReadBack)"]
          why: '''In every cycle the check compares field `keeper_en` of the pad's `dio_attr_o` with the read-back of `DIO_PAD_ATTR_d`.'''
          milestone: "V2"
          priority: "2"
          security: false
          state: "open"
        }
        {
          name: REQ_ATTR_02f
          desc: '''The attribute output of DIO pad `d` shall equal, in field `schmitt_en`, what `DIO_PAD_ATTR_d` reads back.'''
          source: [
            '''!!DIO_PAD_ATTR.schmitt_en'''
            '''[Type RW HWExt](util/reggen/README.md#type-rw-hwext)'''
            '''[Generic Pad Wrapper](hw/top_earlgrey/ip_autogen/pinmux/doc/theory_of_operation.md#generic-pad-wrapper)'''
          ]
          kind: "spec"
          testpoint: "pad_attr"
          checks: ["pad gets read-back (assert_PadAttr_PadGetsReadBack)"]
          why: '''In every cycle the check compares field `schmitt_en` of the pad's `dio_attr_o` with the same field of the read-back of `DIO_PAD_ATTR_d`.'''
          milestone: "V2"
          priority: "2"
          security: false
          state: "open"
        }
        {
          name: REQ_ATTR_02g
          desc: '''The attribute output of DIO pad `d` shall equal, in field `od_en`, what `DIO_PAD_ATTR_d` reads back.'''
          source: [
            '''!!DIO_PAD_ATTR.od_en'''
            '''[Type RW HWExt](util/reggen/README.md#type-rw-hwext)'''
            '''[Generic Pad Wrapper](hw/top_earlgrey/ip_autogen/pinmux/doc/theory_of_operation.md#generic-pad-wrapper)'''
          ]
          kind: "spec"
          testpoint: "pad_attr"
          checks: ["pad gets read-back (assert_PadAttr_PadGetsReadBack)"]
          why: '''In every cycle the check compares field `od_en` of the pad's `dio_attr_o` with the read-back of `DIO_PAD_ATTR_d`.'''
          milestone: "V2"
          priority: "2"
          security: false
          state: "open"
        }
        {
          name: REQ_ATTR_02h
          desc: '''The attribute output of DIO pad `d` shall equal, in field `input_disable`, what `DIO_PAD_ATTR_d` reads back.'''
          source: [
            '''!!DIO_PAD_ATTR.input_disable'''
            '''[Type RW HWExt](util/reggen/README.md#type-rw-hwext)'''
            '''[Generic Pad Wrapper](hw/top_earlgrey/ip_autogen/pinmux/doc/theory_of_operation.md#generic-pad-wrapper)'''
          ]
          kind: "spec"
          testpoint: "pad_attr"
          checks: ["pad gets read-back (assert_PadAttr_PadGetsReadBack)"]
          why: '''In every cycle the check compares field `input_disable` of the pad's `dio_attr_o` with the read-back of `DIO_PAD_ATTR_d`.'''
          milestone: "V2"
          priority: "2"
          security: false
          state: "open"
        }
        {
          name: REQ_ATTR_02i
          desc: '''The attribute output of DIO pad `d` shall equal, in field `slew_rate`, what `DIO_PAD_ATTR_d` reads back.'''
          source: [
            '''!!DIO_PAD_ATTR.slew_rate'''
            '''[Type RW HWExt](util/reggen/README.md#type-rw-hwext)'''
            '''[Generic Pad Wrapper](hw/top_earlgrey/ip_autogen/pinmux/doc/theory_of_operation.md#generic-pad-wrapper)'''
          ]
          kind: "spec"
          testpoint: "pad_attr"
          checks: ["pad gets read-back (assert_PadAttr_PadGetsReadBack)"]
          why: '''In every cycle the check compares both bits of field `slew_rate` of the pad's `dio_attr_o` with the read-back of `DIO_PAD_ATTR_d`.'''
          milestone: "V2"
          priority: "2"
          security: false
          state: "open"
        }
        {
          name: REQ_ATTR_02j
          desc: '''The attribute output of DIO pad `d` shall equal, in field `drive_strength`, what `DIO_PAD_ATTR_d` reads back.'''
          source: [
            '''!!DIO_PAD_ATTR.drive_strength'''
            '''[Type RW HWExt](util/reggen/README.md#type-rw-hwext)'''
            '''[Generic Pad Wrapper](hw/top_earlgrey/ip_autogen/pinmux/doc/theory_of_operation.md#generic-pad-wrapper)'''
          ]
          kind: "spec"
          testpoint: "pad_attr"
          checks: ["pad gets read-back (assert_PadAttr_PadGetsReadBack)"]
          why: '''In every cycle the check compares the four bits of field `drive_strength` of the pad's `dio_attr_o` with the read-back of `DIO_PAD_ATTR_d`.'''
          milestone: "V2"
          priority: "2"
          security: false
          state: "open"
        }
        {
          name: REQ_ATTR_03
          desc: '''The `invert` field of every pad shall read back as written.'''
          source: [
            '''[Generic Pad Wrapper](hw/top_earlgrey/ip_autogen/pinmux/doc/theory_of_operation.md#generic-pad-wrapper)'''
          ]
          kind: "spec"
          testpoint: "pad_attr"
          checks: ["invert reads back (assert_PadAttr_InvertReadsBack)"]
          why: '''On every pad type, the check compares the `invert` bit of the read-back with that of the pad's last attribute write.'''
          milestone: "V2"
          priority: "2"
          security: false
          state: "open"
        }
        {
          name: REQ_ATTR_04
          desc: '''The `od_en` field of a BidirOd pad shall read back as written.'''
          source: [
            '''[Open drain / virtual open drain](hw/top_earlgrey/doc/design/README.md#open-drain--virtual-open-drain)'''
            '''[top_earlgrey.hjson `pinout.pads`](hw/top_earlgrey/data/top_earlgrey.hjson)'''
          ]
          kind: "spec"
          testpoint: "pad_attr"
          checks: ["open drain reads back (assert_PadAttr_OpenDrainReadsBack)"]
          why: '''On every BidirOd pad, the check compares the `od_en` bit of the read-back with that of the pad's last attribute write.'''
          milestone: "V2"
          priority: "2"
          security: false
          state: "open"
        }
        {
          name: REQ_ATTR_05
          desc: '''The `virtual_od_en` field of a BidirStd pad shall read back as written.'''
          source: [
            '''[Open drain / virtual open drain](hw/top_earlgrey/doc/design/README.md#open-drain--virtual-open-drain)'''
            '''[top_earlgrey.hjson `pinout.pads`](hw/top_earlgrey/data/top_earlgrey.hjson)'''
          ]
          kind: "spec"
          testpoint: "pad_attr"
          checks: ["virtual open drain reads back (assert_PadAttr_VirtualOpenDrainReadsBack)"]
          why: '''On every BidirStd pad, the check compares the `virtual_od_en` bit of the read-back with that of the last attribute write.'''
          milestone: "V2"
          priority: "2"
          security: false
          state: "open"
        }
        {
          name: REQ_ATTR_06
          desc: '''The `od_en` field of every pad not of type BidirOd shall read back 0.'''
          source: [
            '''[Open drain / virtual open drain](hw/top_earlgrey/doc/design/README.md#open-drain--virtual-open-drain)'''
            '''[Pad Attributes](hw/top_earlgrey/ip_autogen/pinmux/doc/programmers_guide.md#pad-attributes)'''
            '''[top_earlgrey.hjson `pinout.pads`](hw/top_earlgrey/data/top_earlgrey.hjson)'''
          ]
          kind: "spec"
          testpoint: "pad_attr"
          checks: ["no open drain elsewhere (assert_PadAttr_NoOpenDrainElsewhere)"]
          why: '''On every pad not of type BidirOd, the check requires the `od_en` bit of the read-back to be 0, whatever software wrote.'''
          milestone: "V2"
          priority: "2"
          security: false
          state: "open"
        }
        {
          name: REQ_ATTR_07
          desc: '''The `virtual_od_en` field of every pad not of type BidirStd shall read back 0.'''
          source: [
            '''[Open drain / virtual open drain](hw/top_earlgrey/doc/design/README.md#open-drain--virtual-open-drain)'''
            '''[Pad Attributes](hw/top_earlgrey/ip_autogen/pinmux/doc/programmers_guide.md#pad-attributes)'''
            '''[top_earlgrey.hjson `pinout.pads`](hw/top_earlgrey/data/top_earlgrey.hjson)'''
          ]
          kind: "spec"
          testpoint: "pad_attr"
          checks: ["no virtual open drain elsewhere (assert_PadAttr_NoVirtualOpenDrainElsewhere)"]
          why: '''On every pad not of type BidirStd, the check requires the `virtual_od_en` bit of the read-back to be 0, whatever software wrote.'''
          milestone: "V2"
          priority: "2"
          security: false
          state: "open"
        }
        {
          name: REQ_ATTR_08c
          desc: '''The field `pull_en` shall read back as written where the pad's type keeps the field.'''
          source: [
            '''!!MIO_PAD_ATTR'''
            '''[Pad Attributes](hw/top_earlgrey/ip_autogen/pinmux/doc/programmers_guide.md#pad-attributes)'''
            '''[top_earlgrey.hjson `pinout.pads`](hw/top_earlgrey/data/top_earlgrey.hjson)'''
          ]
          kind: "spec"
          testpoint: "pad_attr"
          checks: ["supported bits read back (assert_PadAttr_SupportedBitsReadBack)"]
          why: '''The check requires `pull_en` to read back a written 0, and a written 1 once a pad of its type has read one back.'''
          milestone: "V2"
          priority: "2"
          security: false
          state: "open"
        }
        {
          name: REQ_ATTR_08d
          desc: '''The field `pull_select` shall read back as written where the pad's type keeps the field.'''
          source: [
            '''!!MIO_PAD_ATTR'''
            '''[Pad Attributes](hw/top_earlgrey/ip_autogen/pinmux/doc/programmers_guide.md#pad-attributes)'''
            '''[top_earlgrey.hjson `pinout.pads`](hw/top_earlgrey/data/top_earlgrey.hjson)'''
          ]
          kind: "spec"
          testpoint: "pad_attr"
          checks: ["supported bits read back (assert_PadAttr_SupportedBitsReadBack)"]
          why: '''The check requires `pull_select` to read back a written 0, and a written 1 once a pad of its type has read one back.'''
          milestone: "V2"
          priority: "2"
          security: false
          state: "open"
        }
        {
          name: REQ_ATTR_08e
          desc: '''The field `keeper_en` shall read back as written where the pad's type keeps the field.'''
          source: [
            '''!!MIO_PAD_ATTR'''
            '''[Pad Attributes](hw/top_earlgrey/ip_autogen/pinmux/doc/programmers_guide.md#pad-attributes)'''
            '''[top_earlgrey.hjson `pinout.pads`](hw/top_earlgrey/data/top_earlgrey.hjson)'''
          ]
          kind: "spec"
          testpoint: "pad_attr"
          checks: ["supported bits read back (assert_PadAttr_SupportedBitsReadBack)"]
          why: '''The check requires `keeper_en` to read back a written 0, and a written 1 once a pad of its type has read one back.'''
          milestone: "V2"
          priority: "2"
          security: false
          state: "open"
        }
        {
          name: REQ_ATTR_08f
          desc: '''The field `schmitt_en` shall read back as written where the pad's type keeps the field.'''
          source: [
            '''!!MIO_PAD_ATTR'''
            '''[Pad Attributes](hw/top_earlgrey/ip_autogen/pinmux/doc/programmers_guide.md#pad-attributes)'''
            '''[top_earlgrey.hjson `pinout.pads`](hw/top_earlgrey/data/top_earlgrey.hjson)'''
          ]
          kind: "spec"
          testpoint: "pad_attr"
          checks: ["supported bits read back (assert_PadAttr_SupportedBitsReadBack)"]
          why: '''The check requires `schmitt_en` to read back a written 0, and a written 1 once a pad of its type has read one back.'''
          milestone: "V2"
          priority: "2"
          security: false
          state: "open"
        }
        {
          name: REQ_ATTR_08g
          desc: '''The field `input_disable` shall read back as written where the pad's type keeps the field.'''
          source: [
            '''!!MIO_PAD_ATTR'''
            '''[Pad Attributes](hw/top_earlgrey/ip_autogen/pinmux/doc/programmers_guide.md#pad-attributes)'''
            '''[top_earlgrey.hjson `pinout.pads`](hw/top_earlgrey/data/top_earlgrey.hjson)'''
          ]
          kind: "spec"
          testpoint: "pad_attr"
          checks: ["supported bits read back (assert_PadAttr_SupportedBitsReadBack)"]
          why: '''The check requires `input_disable` to read back a written 0, and a written 1 once a pad of its type has read one back.'''
          milestone: "V2"
          priority: "2"
          security: false
          state: "open"
        }
        {
          name: REQ_ATTR_08h
          desc: '''Each bit of the field `slew_rate` shall read back as written where the pad's type keeps that bit.'''
          source: [
            '''!!MIO_PAD_ATTR'''
            '''[Pad Attributes](hw/top_earlgrey/ip_autogen/pinmux/doc/programmers_guide.md#pad-attributes)'''
            '''[top_earlgrey.hjson `pinout.pads`](hw/top_earlgrey/data/top_earlgrey.hjson)'''
          ]
          kind: "spec"
          testpoint: "pad_attr"
          checks: ["supported bits read back (assert_PadAttr_SupportedBitsReadBack)"]
          why: '''The check requires each bit of `slew_rate` to read back a written 0, and a written 1 once a pad of its type has read one back.'''
          milestone: "V2"
          priority: "2"
          security: false
          state: "open"
        }
        {
          name: REQ_ATTR_08i
          desc: '''Each bit of the field `drive_strength` shall read back as written where the pad's type keeps that bit.'''
          source: [
            '''!!MIO_PAD_ATTR'''
            '''[Pad Attributes](hw/top_earlgrey/ip_autogen/pinmux/doc/programmers_guide.md#pad-attributes)'''
            '''[top_earlgrey.hjson `pinout.pads`](hw/top_earlgrey/data/top_earlgrey.hjson)'''
          ]
          kind: "spec"
          testpoint: "pad_attr"
          checks: ["supported bits read back (assert_PadAttr_SupportedBitsReadBack)"]
          why: '''The check requires each bit of `drive_strength` to read back a written 0, and a written 1 once a pad of its type has read one back.'''
          milestone: "V2"
          priority: "2"
          security: false
          state: "open"
        }
        {
          name: REQ_ATTR_09c
          desc: '''The field `pull_en` shall read back 0 where the pad's type does not keep the field.'''
          source: [
            '''[Pad Attributes](hw/top_earlgrey/ip_autogen/pinmux/doc/programmers_guide.md#pad-attributes)'''
            '''[top_earlgrey.hjson `pinout.pads`](hw/top_earlgrey/data/top_earlgrey.hjson)'''
          ]
          kind: "spec"
          testpoint: "pad_attr"
          checks: ["unsupported bits read 0 (assert_PadAttr_UnsupportedBitsRead0)"]
          why: '''The check requires `pull_en` to read back a written 0, and 0 on every pad of its type once one read a written 1 as 0.'''
          milestone: "V2"
          priority: "2"
          security: false
          state: "open"
        }
        {
          name: REQ_ATTR_09d
          desc: '''The field `pull_select` shall read back 0 where the pad's type does not keep the field.'''
          source: [
            '''[Pad Attributes](hw/top_earlgrey/ip_autogen/pinmux/doc/programmers_guide.md#pad-attributes)'''
            '''[top_earlgrey.hjson `pinout.pads`](hw/top_earlgrey/data/top_earlgrey.hjson)'''
          ]
          kind: "spec"
          testpoint: "pad_attr"
          checks: ["unsupported bits read 0 (assert_PadAttr_UnsupportedBitsRead0)"]
          why: '''The check requires `pull_select` to read back a written 0, and 0 on every pad of its type once one read a written 1 as 0.'''
          milestone: "V2"
          priority: "2"
          security: false
          state: "open"
        }
        {
          name: REQ_ATTR_09e
          desc: '''The field `keeper_en` shall read back 0 where the pad's type does not keep the field.'''
          source: [
            '''[Pad Attributes](hw/top_earlgrey/ip_autogen/pinmux/doc/programmers_guide.md#pad-attributes)'''
            '''[top_earlgrey.hjson `pinout.pads`](hw/top_earlgrey/data/top_earlgrey.hjson)'''
          ]
          kind: "spec"
          testpoint: "pad_attr"
          checks: ["unsupported bits read 0 (assert_PadAttr_UnsupportedBitsRead0)"]
          why: '''The check requires `keeper_en` to read back a written 0, and 0 on every pad of its type once one read a written 1 as 0.'''
          milestone: "V2"
          priority: "2"
          security: false
          state: "open"
        }
        {
          name: REQ_ATTR_09f
          desc: '''The field `schmitt_en` shall read back 0 where the pad's type does not keep the field.'''
          source: [
            '''[Pad Attributes](hw/top_earlgrey/ip_autogen/pinmux/doc/programmers_guide.md#pad-attributes)'''
            '''[top_earlgrey.hjson `pinout.pads`](hw/top_earlgrey/data/top_earlgrey.hjson)'''
          ]
          kind: "spec"
          testpoint: "pad_attr"
          checks: ["unsupported bits read 0 (assert_PadAttr_UnsupportedBitsRead0)"]
          why: '''The check requires `schmitt_en` to read back a written 0, and 0 on every pad of its type once one read a written 1 as 0.'''
          milestone: "V2"
          priority: "2"
          security: false
          state: "open"
        }
        {
          name: REQ_ATTR_09g
          desc: '''The field `input_disable` shall read back 0 where the pad's type does not keep the field.'''
          source: [
            '''[Pad Attributes](hw/top_earlgrey/ip_autogen/pinmux/doc/programmers_guide.md#pad-attributes)'''
            '''[top_earlgrey.hjson `pinout.pads`](hw/top_earlgrey/data/top_earlgrey.hjson)'''
          ]
          kind: "spec"
          testpoint: "pad_attr"
          checks: ["unsupported bits read 0 (assert_PadAttr_UnsupportedBitsRead0)"]
          why: '''The check requires `input_disable` to read back a written 0, and 0 on every pad of its type once one read a written 1 as 0.'''
          milestone: "V2"
          priority: "2"
          security: false
          state: "open"
        }
        {
          name: REQ_ATTR_09h
          desc: '''Each bit of the field `slew_rate` shall read back 0 where the pad's type does not keep that bit.'''
          source: [
            '''[Pad Attributes](hw/top_earlgrey/ip_autogen/pinmux/doc/programmers_guide.md#pad-attributes)'''
            '''[top_earlgrey.hjson `pinout.pads`](hw/top_earlgrey/data/top_earlgrey.hjson)'''
          ]
          kind: "spec"
          testpoint: "pad_attr"
          checks: ["unsupported bits read 0 (assert_PadAttr_UnsupportedBitsRead0)"]
          why: '''The check requires each bit of `slew_rate` to read back a written 0, and 0 on every pad of its type once one read a written 1 as 0.'''
          milestone: "V2"
          priority: "2"
          security: false
          state: "open"
        }
        {
          name: REQ_ATTR_09i
          desc: '''Each bit of the field `drive_strength` shall read back 0 where the pad's type does not keep that bit.'''
          source: [
            '''[Pad Attributes](hw/top_earlgrey/ip_autogen/pinmux/doc/programmers_guide.md#pad-attributes)'''
            '''[top_earlgrey.hjson `pinout.pads`](hw/top_earlgrey/data/top_earlgrey.hjson)'''
          ]
          kind: "spec"
          testpoint: "pad_attr"
          checks: ["unsupported bits read 0 (assert_PadAttr_UnsupportedBitsRead0)"]
          why: '''The check requires each bit of `drive_strength` to read back a written 0, and 0 on every pad of its type once one read a written 1 as 0.'''
          milestone: "V2"
          priority: "2"
          security: false
          state: "open"
        }
        {
          name: REQ_ATTR_10
          desc: '''After reset, each pad's attribute output shall be its reset value, 0 in fields its type does not keep. All are 0 but `pull_en` of MIO pad 30 (IOC8), which is 1.'''
          source: [
            '''!!MIO_PAD_ATTR'''
            '''!!DIO_PAD_ATTR'''
            '''[top_earlgrey.hjson `pinout`](hw/top_earlgrey/data/top_earlgrey.hjson)'''
            '''[top_earlgrey.hjson `pinout.pads IOC8`](hw/top_earlgrey/data/top_earlgrey.hjson)'''
            '''[top_earlgrey.hjson `targets.asic.pinmux.special_signals tap0`](hw/top_earlgrey/data/top_earlgrey.hjson)'''
          ]
          kind: "spec"
          testpoint: "pad_attr"
          checks: ["reset attributes (assert_PadAttr_ResetAttributes)"]
          why: '''Until the pad's first attribute write after reset, the check compares the pad's attribute output with the reset attributes.'''
          milestone: "V2"
          priority: "2"
          security: false
          state: "open"
        }
      ]
    }
    {
      name: '''Sleep retention'''
      conditions: [
        '''"pad" is MIO pad `p` or DIO pad `d`; "status bit" is its bit in `MIO_PAD_SLEEP_STATUS` or `DIO_PAD_SLEEP_STATUS`. "Sleep entry" is a rise of `sleep_en_i`. The mode rows hold while no TAP owns the pad and the sleep mode is unchanged since sleep entry.'''
      ]
      requirements: [
        {
          name: REQ_SLP_01
          desc: '''At sleep entry, the status bit of every pad whose sleep enable is 1 shall become 1, unless a software clear of that bit lands in the same cycle (`REQ_SLP_09`).'''
          source: [
            '''!!MIO_PAD_SLEEP_EN.EN'''
            '''[Sleep Features](hw/top_earlgrey/ip_autogen/pinmux/doc/programmers_guide.md#sleep-features)'''
          ]
          kind: "spec"
          testpoint: "pad_sleep"
          checks: ["bit set at entry (assert_PadSleep_BitSetAtEntry)"]
          why: '''For every sleep entry with the sleep enable at 1 and no software clear of the bit, the check requires the status bit to be 1 in the next cycle.'''
          milestone: "V2"
          priority: "2"
          security: false
          state: "open"
        }
        {
          name: REQ_SLP_02
          desc: '''A status bit shall become 1 only at sleep entry, and only if the pad's sleep enable is 1.'''
          source: [
            '''!!MIO_PAD_SLEEP_STATUS.EN'''
            '''[Sleep Features](hw/top_earlgrey/ip_autogen/pinmux/doc/programmers_guide.md#sleep-features)'''
          ]
          kind: "spec"
          testpoint: "pad_sleep"
          checks: ["bit set only at entry (assert_PadSleep_BitSetOnlyAtEntry)"]
          why: '''For every rise of a status bit the check requires a sleep entry with the pad's sleep enable at 1 in the cycle before.'''
          milestone: "V2"
          priority: "2"
          security: false
          state: "open"
        }
        {
          name: REQ_SLP_03a
          desc: '''While its status bit is 1 and its sleep mode is 0, a pad's output shall be 0.'''
          source: [
            '''!!MIO_PAD_SLEEP_MODE.OUT'''
            '''[Sleep Features](hw/top_earlgrey/ip_autogen/pinmux/doc/programmers_guide.md#sleep-features)'''
          ]
          kind: "spec"
          testpoint: "pad_sleep"
          checks: ["tie low in sleep (assert_PadSleep_TieLowInSleep)"]
          why: '''While the status bit is 1 with mode 0 taken at the entry, the check compares the output of a pad no TAP owns with 0 in the same cycle.'''
          milestone: "V2"
          priority: "2"
          security: false
          state: "open"
        }
        {
          name: REQ_SLP_03b
          desc: '''While its status bit is 1 and its sleep mode is 0, a pad's output enable shall be 1, so the pad drives 0.'''
          source: [
            '''!!MIO_PAD_SLEEP_MODE.OUT'''
            '''[Sleep Features](hw/top_earlgrey/ip_autogen/pinmux/doc/programmers_guide.md#sleep-features)'''
          ]
          kind: "spec"
          testpoint: "pad_sleep"
          checks: ["tie low in sleep (assert_PadSleep_TieLowInSleep)"]
          why: '''While held in mode 0, the check compares the output enable of a pad no TAP owns with 1.'''
          milestone: "V2"
          priority: "2"
          security: false
          state: "open"
        }
        {
          name: REQ_SLP_04a
          desc: '''While its status bit is 1 and its sleep mode is 1, a pad's output shall be 1.'''
          source: [
            '''!!MIO_PAD_SLEEP_MODE.OUT'''
          ]
          kind: "spec"
          testpoint: "pad_sleep"
          checks: ["tie high in sleep (assert_PadSleep_TieHighInSleep)"]
          why: '''While the status bit is 1 with mode 1 taken at the entry, the check compares the output of a pad no TAP owns with 1 in the same cycle.'''
          milestone: "V2"
          priority: "2"
          security: false
          state: "open"
        }
        {
          name: REQ_SLP_04b
          desc: '''While its status bit is 1 and its sleep mode is 1, a pad's output enable shall be 1, so the pad drives 1.'''
          source: [
            '''!!MIO_PAD_SLEEP_MODE.OUT'''
          ]
          kind: "spec"
          testpoint: "pad_sleep"
          checks: ["tie high in sleep (assert_PadSleep_TieHighInSleep)"]
          why: '''While held in mode 1, the check compares the output enable of a pad no TAP owns with 1.'''
          milestone: "V2"
          priority: "2"
          security: false
          state: "open"
        }
        {
          name: REQ_SLP_05a
          desc: '''While its status bit is 1 and its sleep mode is 2, a pad's output enable shall be 0: the pad is high-Z.'''
          source: [
            '''!!MIO_PAD_SLEEP_MODE.OUT'''
          ]
          kind: "spec"
          testpoint: "pad_sleep"
          checks: ["high-Z in sleep (assert_PadSleep_HighZInSleep)"]
          why: '''While the status bit is 1 with mode 2 taken at the entry, the check compares the output enable of a pad no TAP owns with 0 in the same cycle.'''
          milestone: "V2"
          priority: "2"
          security: false
          state: "open"
        }
        {
          name: REQ_SLP_05b
          desc: '''While its status bit is 1 and its sleep mode is 2, a pad's output shall be 0.'''
          source: [
            '''!!MIO_PAD_SLEEP_MODE.OUT'''
          ]
          kind: "spec"
          testpoint: "pad_sleep"
          checks: ["high-Z in sleep (assert_PadSleep_HighZInSleep)"]
          why: '''While held in mode 2, the check compares the output of a pad no TAP owns with 0.'''
          milestone: "V2"
          priority: "2"
          security: false
          state: "open"
        }
        {
          name: REQ_SLP_06a
          desc: '''While its status bit is 1 and its sleep mode is 3, a pad shall keep the output it drove in the last cycle before the bit became 1.'''
          source: [
            '''!!MIO_PAD_SLEEP_MODE.OUT'''
            '''[Retention Logic](hw/top_earlgrey/ip_autogen/pinmux/doc/theory_of_operation.md#retention-logic)'''
          ]
          kind: "spec"
          testpoint: "pad_sleep"
          checks: ["keep holds (assert_PadSleep_KeepHolds)"]
          why: '''While held in mode 3, the check compares a pad's output with its output at the sleep entry that set the bit, if no TAP owned it then or now.'''
          milestone: "V2"
          priority: "2"
          security: false
          state: "open"
        }
        {
          name: REQ_SLP_06b
          desc: '''While its status bit is 1 and its sleep mode is 3, a pad shall keep the output enable it drove in the last cycle before the bit became 1.'''
          source: [
            '''!!MIO_PAD_SLEEP_MODE.OUT'''
            '''[Retention Logic](hw/top_earlgrey/ip_autogen/pinmux/doc/theory_of_operation.md#retention-logic)'''
          ]
          kind: "spec"
          testpoint: "pad_sleep"
          checks: ["keep holds (assert_PadSleep_KeepHolds)"]
          why: '''While held in mode 3, the check compares a pad's output enable with its enable at the sleep entry that set the bit, if no TAP owned it then or now.'''
          milestone: "V2"
          priority: "2"
          security: false
          state: "open"
        }
        {
          name: REQ_SLP_07
          desc: '''Once 1, a status bit shall stay 1 until software writes 0 to it, whatever `sleep_en_i`, the sleep enable and the peripheral do.'''
          source: [
            '''!!MIO_PAD_SLEEP_STATUS.EN'''
            '''[Retention Logic](hw/top_earlgrey/ip_autogen/pinmux/doc/theory_of_operation.md#retention-logic)'''
          ]
          kind: "spec"
          testpoint: "pad_sleep"
          checks: ["bit holds until cleared (assert_PadSleep_BitHoldsUntilCleared)", "clear releases (assert_PadSleep_ClearReleases)"]
          why: '''The first fails a bit at 1 that falls without a software clear; the second requires 0 in the cycle after a clear.'''
          milestone: "V2"
          priority: "2"
          security: false
          state: "open"
        }
        {
          name: REQ_SLP_08
          desc: '''While its status bit is 0, an MIO pad shall drive what its output select names, and a DIO pad the output and output enable of its own peripheral.'''
          source: [
            '''[Retention Logic](hw/top_earlgrey/ip_autogen/pinmux/doc/theory_of_operation.md#retention-logic)'''
            '''[Sleep Features](hw/top_earlgrey/ip_autogen/pinmux/doc/programmers_guide.md#sleep-features)'''
          ]
          kind: "spec"
          testpoint: "sleep_release"
          checks: ["tie 0 drives 0 (assert_PadOutput_Tie0Drives0)", "tie 1 drives 1 (assert_PadOutput_Tie1Drives1)", "select 2 is high-Z (assert_PadOutput_Select2IsHighZ)", "drives selected output (assert_PadOutput_DrivesSelectedOutput)", "no output is high-Z (assert_PadOutput_NoOutputIsHighZ)", "DIO drives its peripheral (assert_PadOutput_DioDrivesItsPeripheral)"]
          why: '''Each holds while the bit is 0.'''
          milestone: "V2"
          priority: "2"
          security: false
          state: "open"
        }
        {
          name: REQ_SLP_09
          desc: '''When sleep entry sets a status bit in the cycle software writes 0 to that bit, the bit shall end 0: software's clear wins.'''
          source: [
            '''!!MIO_PAD_SLEEP_STATUS'''
            '''[Type RW](util/reggen/README.md#type-rw)'''
            '''[Simultaneous SW and HW access](util/reggen/README.md#simultaneous-sw-and-hw-access)'''
          ]
          kind: "spec"
          testpoint: "pad_sleep"
          checks: ["clear wins (assert_PadSleep_ClearWins)"]
          why: '''For a sleep entry with the sleep enable at 1 in the cycle of a software clear of the bit, the check requires the bit to be 0 in the next cycle.'''
          milestone: "V2"
          priority: "2"
          security: false
          state: "open"
        }
        {
          name: REQ_SLP_10a
          desc: '''A write to a pad's sleep mode while its status bit is 1 shall leave the pad as it is.'''
          source: [
            '''[Retention Logic](hw/top_earlgrey/ip_autogen/pinmux/doc/theory_of_operation.md#retention-logic)'''
            '''[Sleep Features](hw/top_earlgrey/ip_autogen/pinmux/doc/programmers_guide.md#sleep-features)'''
          ]
          kind: "spec"
          testpoint: "pad_sleep"
          checks: ["mode write while held (assert_PadSleep_ModeWriteWhileHeld)"]
          why: '''After a sleep mode write while the bit is 1, the check requires the pad to keep the sleep value of the mode taken at the entry.'''
          milestone: "V2"
          priority: "2"
          security: false
          state: "open"
        }
        {
          name: REQ_SLP_10b
          desc: '''After a write to a pad's sleep mode while its status bit is 1, the new mode shall act at the next sleep entry.'''
          source: [
            '''[Retention Logic](hw/top_earlgrey/ip_autogen/pinmux/doc/theory_of_operation.md#retention-logic)'''
            '''[Sleep Features](hw/top_earlgrey/ip_autogen/pinmux/doc/programmers_guide.md#sleep-features)'''
          ]
          kind: "spec"
          testpoint: "pad_sleep"
          checks: ["tie low in sleep (assert_PadSleep_TieLowInSleep)", "tie high in sleep (assert_PadSleep_TieHighInSleep)", "high-Z in sleep (assert_PadSleep_HighZInSleep)", "keep holds (assert_PadSleep_KeepHolds)", "the CSR checker"]
          why: '''Each uses the mode taken at entry; the CSR checker checks the write is kept.'''
          milestone: "V2"
          priority: "2"
          security: false
          state: "open"
        }
      ]
    }
    {
      name: '''Register locks'''
      conditions: [
        '''"lock" is one bit of a `*_REGWEN` register; it locks the registers of the same index, and is open at 1 and closed at 0. The rule that a locked pad's attributes do not change (`REQ_LOCK_03a`, `REQ_LOCK_03b`) holds except on a JTAG pad while a TAP owns it.'''
      ]
      requirements: [
        {
          name: REQ_LOCK_01a
          desc: '''Every lock shall read 1 after reset.'''
          source: [
            '''the register description: the `EN` field of each `*_REGWEN`, e.g. !!MIO_PAD_ATTR_REGWEN.EN `resval: "1"`, on `clk_i` with `rst_ni` ([pinmux.hjson `clocking`](hw/top_earlgrey/ip_autogen/pinmux/data/pinmux.hjson))'''
            '''[Configuration and Register Definition File Format](util/reggen/README.md#configuration-and-register-definition-file-format)'''
          ]
          kind: "spec"
          testpoint: "fpv_csr_rw"
          checks: ["the CSR checker"]
          why: '''After reset the CSR checker expects every lock, bit 31 of `ALERT_TEST` included, at 1 and compares its value and read with it.'''
          milestone: "V2"
          priority: "2"
          security: true
          state: "open"
        }
        {
          name: REQ_LOCK_01b
          desc: '''Once software writes 0 to a lock, the lock shall stay 0 until reset.'''
          source: [
            '''[Configuration and Register Definition File Format](util/reggen/README.md#configuration-and-register-definition-file-format)'''
            '''[Pad Attributes](hw/top_earlgrey/ip_autogen/pinmux/doc/programmers_guide.md#pad-attributes)'''
          ]
          kind: "spec"
          testpoint: "fpv_csr_rw"
          checks: ["the CSR checker"]
          why: '''The CSR checker predicts each lock as `rw0c`: an accepted write of 0 clears it and nothing sets it; a lock that returns to 1 before a reset fails the compare.'''
          milestone: "V2"
          priority: "2"
          security: true
          state: "open"
        }
        {
          name: REQ_LOCK_01c
          desc: '''A write of 1 to a lock that is 0 shall not reopen it.'''
          source: [
            '''the register description: each lock `rw0c`'''
            '''[Configuration and Register Definition File Format](util/reggen/README.md#configuration-and-register-definition-file-format)'''
            '''[Pinmux Configuration](hw/top_earlgrey/ip_autogen/pinmux/doc/programmers_guide.md#pinmux-configuration)'''
          ]
          kind: "spec"
          testpoint: "fpv_csr_rw"
          checks: ["the CSR checker"]
          why: '''The CSR checker predicts each lock as `rw0c`, which keeps a closed lock at 0 over a write of 1; a lock that such a write reopens fails the compare.'''
          milestone: "V2"
          priority: "2"
          security: true
          state: "open"
        }
        {
          name: REQ_LOCK_02
          desc: '''While a lock is 0, a write to a register it locks shall leave that register unchanged.'''
          source: [
            '''!!MIO_PERIPH_INSEL_REGWEN.EN'''
            '''[Configuration and Register Definition File Format](util/reggen/README.md#configuration-and-register-definition-file-format)'''
          ]
          kind: "spec"
          testpoint: "fpv_csr_rw"
          checks: ["locked read-back holds (assert_Regwen_LockedReadBackHolds)", "the CSR checker"]
          why: '''The CSR checker holds a register whose lock reads 0 over writes; _locked read-back holds_ decides the attribute registers.'''
          milestone: "V2"
          priority: "2"
          security: true
          state: "open"
        }
        {
          name: REQ_LOCK_03a
          desc: '''While a pad's attribute lock is 0, its attribute output shall not change.'''
          source: [
            '''!!MIO_PAD_ATTR_REGWEN.EN'''
            '''[Pad Attributes](hw/top_earlgrey/ip_autogen/pinmux/doc/programmers_guide.md#pad-attributes)'''
          ]
          kind: "spec"
          testpoint: "regwen"
          checks: ["locked attribute holds (assert_Regwen_LockedAttributeHolds)"]
          why: '''It holds the pad's attribute output over every cycle its lock is closed, on a pad no TAP owns.'''
          milestone: "V2"
          priority: "2"
          security: true
          state: "open"
        }
        {
          name: REQ_LOCK_03b
          desc: '''While a pad's attribute lock is 0, what its attribute register reads back shall not change.'''
          source: [
            '''!!MIO_PAD_ATTR_REGWEN.EN'''
            '''[Pad Attributes](hw/top_earlgrey/ip_autogen/pinmux/doc/programmers_guide.md#pad-attributes)'''
          ]
          kind: "spec"
          testpoint: "regwen"
          checks: ["locked read-back holds (assert_Regwen_LockedReadBackHolds)"]
          why: '''It holds each pad's read-back over every cycle its lock is closed, an owned JTAG pad included.'''
          milestone: "V2"
          priority: "2"
          security: true
          state: "open"
        }
      ]
    }
    {
      name: '''Register block and bus'''
      conditions: [
        '''a "failed request" is one whose command integrity code does not match, or a write whose data integrity code does not match ([Usage of User Bits](hw/ip/tlul/README.md#usage-of-user-bits)). No row checks the response or the alert of a read whose only mismatch is in its data code. The "in-band reset" is the alert handler's re-initialization. During it, the handler puts a signal integrity error on its ping and acknowledge pairs on purpose ([Employed Solution](hw/top_earlgrey/ip_autogen/alert_handler/doc/theory_of_operation.md#employed-solution)). An "illegal combination of address, size and mask" is an address not aligned to its size, a size above 2, or a mask bit set outside the access. It is also a `PutFullData` mask with a lane of the access at 0.'''
      ]
      requirements: [
        {
          name: REQ_REG_01a
          desc: '''Every register field shall act as its access type says on software reads and writes answered without an error, a write while its lock reads 1 or it has none.'''
          source: [
            '''the register description: each field's `swaccess`, e.g. !!MIO_PAD_SLEEP_STATUS `swaccess: "rw0c"`'''
            '''[Configuration and Register Definition File Format](util/reggen/README.md#configuration-and-register-definition-file-format)'''
          ]
          kind: "spec"
          testpoint: "fpv_csr_rw"
          checks: ["read-back changes only on a write (assert_PadAttr_ReadBackChangesOnlyOnAWrite)", "the CSR checker"]
          why: '''The CSR checker predicts each field from its access type, the pad_attr check the attribute registers.'''
          milestone: "V2"
          priority: "2"
          security: true
          state: "open"
        }
        {
          name: REQ_REG_01b
          desc: '''Every register field shall read its register description reset value after reset.'''
          source: [
            '''the register description: each field's `resval`, e.g. !!MIO_PAD_SLEEP_STATUS.EN `resval: "0"`'''
            '''[Configuration and Register Definition File Format](util/reggen/README.md#configuration-and-register-definition-file-format)'''
          ]
          kind: "spec"
          testpoint: "fpv_csr_rw"
          checks: ["the CSR checker"]
          why: '''After reset the CSR checker expects each field at its reset value; _reset attributes_ decides the attribute registers.'''
          milestone: "V2"
          priority: "2"
          security: true
          state: "open"
        }
        {
          name: REQ_BUS_01a
          desc: '''The pinmux shall answer every request with one response, and only one.'''
          source: [
            '''TileLink 1.9.3 p. 39: "Receipt of request messages must result in the eventual receipt of a response message by the requestor."; p. 30: "it is illegal to receive a response without receiving the request."; p. 46: "In TL-UL, every message fits within a single beat"'''
          ]
          kind: "spec"
          testpoint: "bus"
          checks: ["device rules (assert_Bus_DeviceRules)"]
          why: '''The TL-UL ABVIP's device rules match each response on the pinmux's port to one open request.'''
          milestone: "V2"
          priority: "2"
          security: true
          state: "open"
        }
        {
          name: REQ_BUS_01b
          desc: '''The pinmux shall answer every request by the TL-UL rules with a response that carries the request's source ID.'''
          source: [
            '''[Source ID requirements for device elements](hw/ip/tlul/README.md#source-id-requirements-for-device-elements)'''
          ]
          kind: "spec"
          testpoint: "bus"
          checks: ["device rules (assert_Bus_DeviceRules)"]
          why: '''The TL-UL ABVIP's device rules compare each response's `d_source` with its request's `a_source`.'''
          milestone: "V2"
          priority: "2"
          security: true
          state: "open"
        }
        {
          name: REQ_BUS_01c
          desc: '''Only a failed request, a case of `REQ_BUS_10a` to `REQ_BUS_10d` or one to an address no register maps shall get an error.'''
          source: [
            '''[Explicit Error Cases](hw/ip/tlul/README.md#explicit-error-cases)'''
            '''[Error responses](util/reggen/README.md#error-responses)'''
          ]
          kind: "spec"
          testpoint: "bus"
          checks: ["errors as the register checker predicts", "the CSR checker"]
          why: '''The CSR checker's error checks require `d_error` 1 on a request not failed exactly for a listed cause.'''
          milestone: "V2"
          priority: "2"
          security: true
          state: "open"
        }
        {
          name: REQ_BUS_02a
          desc: '''Every response shall carry the response integrity code over its op code, size and error.'''
          source: [
            '''[Usage of User Bits](hw/ip/tlul/README.md#usage-of-user-bits)'''
            '''[pinmux.hjson `countermeasures` BUS.INTEGRITY](hw/top_earlgrey/ip_autogen/pinmux/data/pinmux.hjson)'''
          ]
          kind: "spec"
          testpoint: "bus"
          checks: ["response codes correct (assert_Bus_ResponseCodesCorrect)"]
          why: '''It recomputes the response code from each response's opcode, size and error with the shared encoder and compares it with the code sent.'''
          milestone: "V2"
          priority: "2"
          security: true
          state: "open"
        }
        {
          name: REQ_BUS_02b
          desc: '''Every response shall carry the data integrity code over its data.'''
          source: [
            '''[Usage of User Bits](hw/ip/tlul/README.md#usage-of-user-bits)'''
            '''[pinmux.hjson `countermeasures` BUS.INTEGRITY](hw/top_earlgrey/ip_autogen/pinmux/data/pinmux.hjson)'''
          ]
          kind: "spec"
          testpoint: "bus"
          checks: ["response codes correct (assert_Bus_ResponseCodesCorrect)"]
          why: '''It recomputes the data code over each response's data with the shared encoder and compares it with the code sent.'''
          milestone: "V2"
          priority: "2"
          security: true
          state: "open"
        }
        {
          name: REQ_BUS_03
          desc: '''A failed request shall get an error response.'''
          source: [
            '''[Usage of User Bits](hw/ip/tlul/README.md#usage-of-user-bits)'''
            '''[cip_base_vseq](hw/dv/sv/cip_lib/README.md#cip_base_vseq)'''
          ]
          kind: "RTL"
          testpoint: "bus"
          checks: ["failed request errors (assert_Bus_FailedRequestErrors)"]
          why: '''It requires `d_error` 1 on the response to every failed request.'''
          milestone: "V2"
          priority: "2"
          security: true
          state: "open"
        }
        {
          name: REQ_BUS_04
          desc: '''A failed write shall change no register.'''
          source: [
            '''[Usage of User Bits](hw/ip/tlul/README.md#usage-of-user-bits)'''
          ]
          kind: "RTL"
          testpoint: "bus"
          checks: ["failed write changes nothing (assert_Bus_FailedWriteChangesNothing)"]
          why: '''It holds every register over a failed write, but for an AON field taking an earlier write not yet landed.'''
          milestone: "V2"
          priority: "2"
          security: true
          state: "open"
        }
        {
          name: REQ_BUS_05
          desc: '''Outside the alert handler's in-band reset, a failed request shall raise the fatal alert `fatal_fault`.'''
          source: [
            '''[pinmux.hjson `alert_list` fatal_fault](hw/top_earlgrey/ip_autogen/pinmux/data/pinmux.hjson)'''
            '''[Employed Solution](hw/top_earlgrey/ip_autogen/alert_handler/doc/theory_of_operation.md#employed-solution)'''
          ]
          kind: "spec"
          testpoint: "alert"
          checks: ["failed request alerts (assert_Alert_FailedRequestAlerts)"]
          why: '''It requires an alert event on `alert_tx_o` within 40 cycles of every failed request.'''
          milestone: "V2S"
          priority: "2"
          security: true
          state: "open"
        }
        {
          name: REQ_BUS_06
          desc: '''Outside the alert handler's in-band reset, once raised, the fatal alert shall be sent again and again until reset.'''
          source: [
            '''[Alerts per Module](doc/contributing/hw/comportability/README.md#alerts-per-module)'''
            '''[Employed Solution](hw/top_earlgrey/ip_autogen/alert_handler/doc/theory_of_operation.md#employed-solution)'''
          ]
          kind: "spec"
          testpoint: "alert"
          checks: ["fatal alert repeats (assert_Alert_FatalAlertRepeats)"]
          why: '''After a failed request it requires an alert event within 40 cycles of every cycle, until reset.'''
          milestone: "V2S"
          priority: "2"
          security: true
          state: "open"
        }
        {
          name: REQ_BUS_07
          desc: '''Outside the alert handler's in-band reset, a write of 1 to `ALERT_TEST` bit 0 not answered with an error, while its bit 31 is 1, shall send one alert event.'''
          source: [
            '''The register page says of bit 0: "Write 1 to trigger one alert event of this kind." (!!ALERT_TEST)'''
            '''[Test Alert Register Creation](doc/contributing/hw/comportability/README.md#test-alert-register-creation)'''
            '''[Employed Solution](hw/top_earlgrey/ip_autogen/alert_handler/doc/theory_of_operation.md#employed-solution)'''
          ]
          kind: "spec"
          testpoint: "alert"
          checks: ["test sends an event (assert_Alert_TestSendsAnEvent)", "no alert without a cause (assert_Alert_NoAlertWithoutACause)"]
          why: '''Each alert test needs an event within 40 cycles, and each event uses up one test credit, so one test gives one event.'''
          milestone: "V2S"
          priority: "2"
          security: true
          state: "open"
        }
        {
          name: REQ_BUS_08
          desc: '''Outside the alert handler's in-band reset, while `ALERT_TEST` bit 31 is 0, a write to its bit 0 that is not a failed request shall send no alert.'''
          source: [
            '''The register page says of bit 31: "Write 0 to disable alert testing until the next reset." (!!ALERT_TEST)'''
            '''[Employed Solution](hw/top_earlgrey/ip_autogen/alert_handler/doc/theory_of_operation.md#employed-solution)'''
          ]
          kind: "spec"
          testpoint: "alert"
          checks: ["no alert without a cause (assert_Alert_NoAlertWithoutACause)"]
          why: '''A write of bit 0 while bit 31 of `ALERT_TEST` is 0 sets no test credit, so an alert event with no other cause fails it.'''
          milestone: "V2S"
          priority: "2"
          security: true
          state: "open"
        }
        {
          name: REQ_BUS_09
          desc: '''Outside the in-band reset and apart from ping answers, the fatal alert shall be sent only after a failed request or an alert test.'''
          source: [
            '''[pinmux.hjson `alert_list` fatal_fault](hw/top_earlgrey/ip_autogen/pinmux/data/pinmux.hjson)'''
            '''[Employed Solution](hw/top_earlgrey/ip_autogen/alert_handler/doc/theory_of_operation.md#employed-solution)'''
          ]
          kind: "spec"
          testpoint: "alert"
          checks: ["no alert without a cause (assert_Alert_NoAlertWithoutACause)"]
          why: '''It allows an alert event only after a failed request or against a ping or test credit, one per event.'''
          milestone: "V2S"
          priority: "2"
          security: true
          state: "open"
        }
        {
          name: REQ_BUS_10a
          desc: '''A request with an *undefined opcode* shall get an error response.'''
          source: [
            '''[Usage of Opcode, Size and Mask](hw/ip/tlul/README.md#usage-of-opcode-size-and-mask)'''
            '''[Error responses](util/reggen/README.md#error-responses)'''
          ]
          kind: "spec"
          testpoint: "bus"
          checks: ["errors as the register checker predicts", "the CSR checker"]
          why: '''The CSR checker's error checks require `d_error` 1 on an undefined opcode, which the run leaves free.'''
          milestone: "V2"
          priority: "2"
          security: true
          state: "open"
        }
        {
          name: REQ_BUS_10b
          desc: '''A request with an *illegal combination of address, size and mask*, as the Conditions above defines it, shall get an error response.'''
          source: [
            '''[Explicit Error Cases](hw/ip/tlul/README.md#explicit-error-cases)'''
            '''TileLink 1.9.3 p. 51: "a_address must be aligned to a_size."'''
          ]
          kind: "spec"
          testpoint: "bus"
          checks: ["errors as the register checker predicts", "the CSR checker"]
          why: '''The CSR checker's error checks require `d_error` 1 on an illegal fit, masks kept contiguous in the run.'''
          milestone: "V2"
          priority: "2"
          security: true
          state: "open"
        }
        {
          name: REQ_BUS_10c
          desc: '''A *write of 8 or 16 bits to an address not aligned to a word* shall get an error response.'''
          source: [
            '''[Error responses](util/reggen/README.md#error-responses)'''
            '''[Explicit Error Cases](hw/ip/tlul/README.md#explicit-error-cases)'''
          ]
          kind: "spec"
          testpoint: "bus"
          checks: ["errors as the register checker predicts", "the CSR checker"]
          why: '''The CSR checker's error checks require `d_error` 1 on an 8 or 16 bit write not aligned to a word.'''
          milestone: "V2"
          priority: "2"
          security: true
          state: "open"
        }
        {
          name: REQ_BUS_10d
          desc: '''A *write narrower than its register*, whose width the location of its fields sets, shall get an error response.'''
          source: [
            '''[Error responses](util/reggen/README.md#error-responses)'''
          ]
          kind: "spec"
          testpoint: "bus"
          checks: ["errors as the register checker predicts", "the CSR checker"]
          why: '''The CSR checker's error checks require `d_error` 1 on a write narrower than its register.'''
          milestone: "V2"
          priority: "2"
          security: true
          state: "open"
        }
        {
          name: REQ_BUS_10e
          desc: '''A request to an *address no register maps*, within the address bits the register block decodes, shall get an error response.'''
          source: [
            '''[Explicit Error Cases](hw/ip/tlul/README.md#explicit-error-cases)'''
            '''[Error responses](util/reggen/README.md#error-responses)'''
          ]
          kind: "spec"
          testpoint: "bus"
          checks: ["errors as the register checker predicts", "the CSR checker"]
          why: '''The CSR checker's error checks require `d_error` 1 on an address no register maps.'''
          milestone: "V2"
          priority: "2"
          security: true
          state: "open"
        }
        {
          name: REQ_BUS_11
          desc: '''A write answered with an error for any reason other than a failed integrity check shall change no register.'''
          source: [
            '''[cip_base_vseq](hw/dv/sv/cip_lib/README.md#cip_base_vseq)'''
            '''[Error responses](util/reggen/README.md#error-responses)'''
          ]
          kind: "spec"
          testpoint: "bus"
          checks: ["error write changes nothing", "the CSR checker"]
          why: '''An error write is no accepted write, so the CSR checker and the attribute and AON no-write checks hold every register.'''
          milestone: "V2"
          priority: "2"
          security: true
          state: "open"
        }
      ]
    }
    {
      name: '''Wakeup detectors'''
      conditions: [
        '''`w` is a detector (0 to 7); a cycle is a `clk_aon_i` cycle; the watched signal and the forwarded value are defined in the Terms.'''
        '''Register values are those the AON logic holds once a write has crossed. The rows hold with the mode unchanged while enabled, the other fields free to change.'''
        '''They hold whatever `sleep_en_i`, `clk_i` (stopped included) and the scan mode do, except scan mode True while the detector watches a scan clock pad.'''
        '''They are checked from the filter's fourth sample after `rst_aon_ni`. The timed rows (`REQ_WKUP_09a` to `REQ_WKUP_10b`) hold for `CNT_TH` 1 and above.'''
      ]
      requirements: [
        {
          name: REQ_WKUP_01
          desc: '''With `MIODIO` 0, the watched signal shall be MIO pad `PADSEL` - 2 for `PADSEL` 2 to 48, and the constant 0 or 1 for `PADSEL` 0 or 1.'''
          source: [
            '''!!MIO_PERIPH_INSEL.IN'''
            '''!!WKUP_DETECTOR.MIODIO'''
            '''!!WKUP_DETECTOR_PADSEL.SEL'''
            '''[Retention and Wakeup Features](hw/top_earlgrey/ip_autogen/pinmux/doc/theory_of_operation.md#retention-and-wakeup-features)'''
            '''[Wakeup Detectors](hw/top_earlgrey/ip_autogen/pinmux/doc/theory_of_operation.md#wakeup-detectors)'''
            '''[top_earlgrey_pinmux.ipconfig.hjson `n_mio_pads`](hw/top_earlgrey/ip_autogen/pinmux/data/top_earlgrey_pinmux.ipconfig.hjson)'''
          ]
          kind: "spec"
          testpoint: "wakeup"
          checks: ["edge sets cause (assert_Wakeup_EdgeSetsCause)", "timed high sets cause (assert_Wakeup_TimedHighSetsCause)", "timed low sets cause (assert_Wakeup_TimedLowSetsCause)", "no false cause (assert_Wakeup_NoFalseCause)"]
          why: '''The checks watch the MIO pad or constant the select names.'''
          milestone: "V2"
          priority: "1"
          security: false
          state: "open"
        }
        {
          name: REQ_WKUP_02
          desc: '''With `MIODIO` 1, the watched signal shall be DIO pad `PADSEL` for `PADSEL` 0 to 15.'''
          source: [
            '''!!WKUP_DETECTOR.MIODIO'''
            '''!!WKUP_DETECTOR_PADSEL.SEL'''
            '''[MIO and DIO Signal Categories](hw/top_earlgrey/ip_autogen/pinmux/doc/theory_of_operation.md#mio-and-dio-signal-categories)'''
            '''[top_earlgrey_pinmux.ipconfig.hjson `n_dio_pads`](hw/top_earlgrey/ip_autogen/pinmux/data/top_earlgrey_pinmux.ipconfig.hjson)'''
          ]
          kind: "spec"
          testpoint: "wakeup"
          checks: ["edge sets cause (assert_Wakeup_EdgeSetsCause)", "no false cause (assert_Wakeup_NoFalseCause)"]
          why: '''The checks watch the forwarded value of the DIO pad the select names.'''
          milestone: "V2"
          priority: "1"
          security: false
          state: "open"
        }
        {
          name: REQ_WKUP_03
          desc: '''A `PADSEL` that names no pad (49 to 63 with `MIODIO` 0, 16 to 63 with `MIODIO` 1) shall give the watched signal 0.'''
          source: [
            '''!!WKUP_DETECTOR_PADSEL.SEL'''
            '''[top_earlgrey_pinmux.ipconfig.hjson `n_mio_pads`, `n_dio_pads`](hw/top_earlgrey/ip_autogen/pinmux/data/top_earlgrey_pinmux.ipconfig.hjson)'''
          ]
          kind: "spec"
          testpoint: "wakeup"
          checks: ["timed low sets cause (assert_Wakeup_TimedLowSetsCause)", "no false cause (assert_Wakeup_NoFalseCause)"]
          why: '''The checks watch 0 on a select that names no pad, so mode 4 must fire and no edge may set the bit.'''
          milestone: "V2"
          priority: "1"
          security: false
          state: "open"
        }
        {
          name: REQ_WKUP_04
          desc: '''With `FILTER` 0, the forwarded value shall be the watched signal as sampled at each `clk_aon_i` edge.'''
          source: [
            '''[Wakeup Detectors](hw/top_earlgrey/ip_autogen/pinmux/doc/theory_of_operation.md#wakeup-detectors)'''
          ]
          kind: "spec"
          testpoint: "wakeup"
          checks: ["edge sets cause (assert_Wakeup_EdgeSetsCause)", "no false cause (assert_Wakeup_NoFalseCause)"]
          why: '''With `FILTER` 0 the forwarded value the checks watch is the pad as sampled, up to 4 cycles late.'''
          milestone: "V2"
          priority: "1"
          security: false
          state: "open"
        }
        {
          name: REQ_WKUP_05
          desc: '''With `FILTER` 1, the forwarded value shall take a new value only once 4 samples in a row have had it.'''
          source: [
            '''!!WKUP_DETECTOR.FILTER'''
          ]
          kind: "spec"
          testpoint: "wakeup"
          checks: ["edge sets cause (assert_Wakeup_EdgeSetsCause)", "no false cause (assert_Wakeup_NoFalseCause)"]
          why: '''A level held for 4 samples is an edge of the forwarded value, and a 3-sample glitch is none.'''
          milestone: "V2"
          priority: "1"
          security: false
          state: "open"
        }
        {
          name: REQ_WKUP_06a
          desc: '''An enabled detector in mode 0 (Posedge) shall detect every rise of the forwarded value.'''
          source: [
            '''!!WKUP_DETECTOR.MODE'''
            '''[Wakeup Detectors](hw/top_earlgrey/ip_autogen/pinmux/doc/theory_of_operation.md#wakeup-detectors)'''
          ]
          kind: "spec"
          testpoint: "wakeup"
          checks: ["posedge sets cause (assert_Wakeup_PosedgeSetsCause)"]
          why: '''It wants a hardware write of 1 within 8 cycles of each rise of the forwarded value, a one-sample pulse included, with `EN` 1 then and 4 cycles on.'''
          milestone: "V2"
          priority: "1"
          security: false
          state: "open"
        }
        {
          name: REQ_WKUP_06b
          desc: '''An enabled detector in mode 0 (Posedge) shall detect only at a rise of the forwarded value.'''
          source: [
            '''!!WKUP_DETECTOR.MODE'''
            '''[Wakeup Detectors](hw/top_earlgrey/ip_autogen/pinmux/doc/theory_of_operation.md#wakeup-detectors)'''
          ]
          kind: "spec"
          testpoint: "wakeup"
          checks: ["no false cause (assert_Wakeup_NoFalseCause)"]
          why: '''In mode 0 it refuses a hardware write of 1 to a cause bit at 0 that no rise of the forwarded value, seen up to 4 cycles late with `EN` 1, answers.'''
          milestone: "V2"
          priority: "1"
          security: false
          state: "open"
        }
        {
          name: REQ_WKUP_07a
          desc: '''An enabled detector in mode 1 (Negedge) shall detect every fall of the forwarded value.'''
          source: [
            '''!!WKUP_DETECTOR.MODE'''
          ]
          kind: "spec"
          testpoint: "wakeup"
          checks: ["negedge sets cause (assert_Wakeup_NegedgeSetsCause)"]
          why: '''It wants a hardware write of 1 to bit `w` within 8 cycles of each fall of the forwarded value with `EN` 1 then and for 4 more cycles.'''
          milestone: "V2"
          priority: "1"
          security: false
          state: "open"
        }
        {
          name: REQ_WKUP_07b
          desc: '''An enabled detector in mode 1 (Negedge) shall detect only at a fall of the forwarded value.'''
          source: [
            '''!!WKUP_DETECTOR.MODE'''
          ]
          kind: "spec"
          testpoint: "wakeup"
          checks: ["no false cause (assert_Wakeup_NoFalseCause)"]
          why: '''In mode 1 it refuses a hardware write of 1 to a cause bit at 0 that no fall of the forwarded value answers: a detector that fires on a rise fails it.'''
          milestone: "V2"
          priority: "1"
          security: false
          state: "open"
        }
        {
          name: REQ_WKUP_08a
          desc: '''An enabled detector in mode 2 (Edge) shall detect every change of the forwarded value.'''
          source: [
            '''!!WKUP_DETECTOR.MODE'''
          ]
          kind: "spec"
          testpoint: "wakeup"
          checks: ["edge sets cause (assert_Wakeup_EdgeSetsCause)"]
          why: '''It wants a hardware write of 1 to bit `w` within 8 cycles of each rise and each fall of the forwarded value with `EN` 1 then and for 4 more cycles.'''
          milestone: "V2"
          priority: "1"
          security: false
          state: "open"
        }
        {
          name: REQ_WKUP_08b
          desc: '''An enabled detector in mode 2 (Edge) shall detect only at a change of the forwarded value.'''
          source: [
            '''!!WKUP_DETECTOR.MODE'''
          ]
          kind: "spec"
          testpoint: "wakeup"
          checks: ["no false cause (assert_Wakeup_NoFalseCause)"]
          why: '''In mode 2 it refuses a hardware write of 1 to a cause bit at 0 that no rise or fall of the forwarded value answers.'''
          milestone: "V2"
          priority: "1"
          security: false
          state: "open"
        }
        {
          name: REQ_WKUP_09a
          desc: '''An enabled detector in mode 3 (TimedHigh) shall detect when the forwarded value has been 1 for `CNT_TH` cycles in a row.'''
          source: [
            '''!!WKUP_DETECTOR.MODE'''
            '''!!WKUP_DETECTOR_CNT_TH.TH'''
            '''[Wakeup Detectors](hw/top_earlgrey/ip_autogen/pinmux/doc/theory_of_operation.md#wakeup-detectors)'''
            '''[top_earlgrey_pinmux.ipconfig.hjson `wkup_cnt_width`](hw/top_earlgrey/ip_autogen/pinmux/data/top_earlgrey_pinmux.ipconfig.hjson)'''
          ]
          kind: "spec"
          testpoint: "wakeup"
          checks: ["timed high sets cause (assert_Wakeup_TimedHighSetsCause)"]
          why: '''It wants the cause bit set within 8 cycles of the forwarded value 1 for `CNT_TH` + 1 cycles in a row with `EN` 1, the later count allowed.'''
          milestone: "V2"
          priority: "1"
          security: false
          state: "open"
        }
        {
          name: REQ_WKUP_09b
          desc: '''An enabled detector in mode 3 (TimedHigh) shall *never detect* while the forwarded value has been 1 for fewer than `CNT_TH` cycles in a row.'''
          source: [
            '''!!WKUP_DETECTOR.MODE'''
            '''[top_earlgrey_pinmux.ipconfig.hjson `wkup_cnt_width`](hw/top_earlgrey/ip_autogen/pinmux/data/top_earlgrey_pinmux.ipconfig.hjson)'''
          ]
          kind: "spec"
          testpoint: "wakeup"
          checks: ["no false cause (assert_Wakeup_NoFalseCause)"]
          why: '''In mode 3 it refuses a set of the cause bit while the forwarded value has been 1 for fewer than `CNT_TH` cycles in a row with `EN` 1.'''
          milestone: "V2"
          priority: "1"
          security: false
          state: "open"
        }
        {
          name: REQ_WKUP_10a
          desc: '''An enabled detector in mode 4 (TimedLow) shall detect when the forwarded value has been 0 for `CNT_TH` cycles in a row.'''
          source: [
            '''!!WKUP_DETECTOR.MODE'''
            '''!!WKUP_DETECTOR_CNT_TH.TH'''
            '''[Wakeup Detectors](hw/top_earlgrey/ip_autogen/pinmux/doc/theory_of_operation.md#wakeup-detectors)'''
            '''[top_earlgrey_pinmux.ipconfig.hjson `wkup_cnt_width`](hw/top_earlgrey/ip_autogen/pinmux/data/top_earlgrey_pinmux.ipconfig.hjson)'''
          ]
          kind: "spec"
          testpoint: "wakeup"
          checks: ["timed low sets cause (assert_Wakeup_TimedLowSetsCause)"]
          why: '''It wants the cause bit set within 8 cycles of the forwarded value 0 for `CNT_TH` + 1 cycles in a row with `EN` 1, the later count allowed.'''
          milestone: "V2"
          priority: "1"
          security: false
          state: "open"
        }
        {
          name: REQ_WKUP_10b
          desc: '''An enabled detector in mode 4 (TimedLow) shall *never detect* while the forwarded value has been 0 for fewer than `CNT_TH` cycles in a row.'''
          source: [
            '''!!WKUP_DETECTOR.MODE'''
            '''[top_earlgrey_pinmux.ipconfig.hjson `wkup_cnt_width`](hw/top_earlgrey/ip_autogen/pinmux/data/top_earlgrey_pinmux.ipconfig.hjson)'''
          ]
          kind: "spec"
          testpoint: "wakeup"
          checks: ["no false cause (assert_Wakeup_NoFalseCause)"]
          why: '''In mode 4 it refuses a set of the cause bit while the forwarded value has been 0 for fewer than `CNT_TH` cycles in a row with `EN` 1.'''
          milestone: "V2"
          priority: "1"
          security: false
          state: "open"
        }
        {
          name: REQ_WKUP_11
          desc: '''An enabled detector in mode 5, 6 or 7 shall detect exactly the rises of the forwarded value, as in mode 0 (Posedge).'''
          source: [
            '''!!WKUP_DETECTOR.MODE'''
          ]
          kind: "spec"
          testpoint: "wakeup"
          checks: ["posedge sets cause (assert_Wakeup_PosedgeSetsCause)", "no false cause (assert_Wakeup_NoFalseCause)"]
          why: '''Both checks read `MODE` 5, 6 and 7 as mode 0.'''
          milestone: "V2"
          priority: "1"
          security: false
          state: "open"
        }
        {
          name: REQ_WKUP_12
          desc: '''A detector whose enable is 0 shall detect nothing.'''
          source: [
            '''!!WKUP_DETECTOR_EN.EN'''
          ]
          kind: "spec"
          testpoint: "wakeup"
          checks: ["no false cause (assert_Wakeup_NoFalseCause)"]
          why: '''It refuses a hardware write of 1 to a cause bit at 0 that no pattern with `EN` 1 answers; an edge within 4 cycles of an enable change may set it or not.'''
          milestone: "V2"
          priority: "1"
          security: false
          state: "open"
        }
        {
          name: REQ_WKUP_13a
          desc: '''The sampling shall run while the detector is disabled, so that enabling the detector does not restart it.'''
          source: [
            '''None: the theory of operation and the register description are silent'''
          ]
          kind: "RTL"
          testpoint: "wakeup"
          checks: ["no false cause (assert_Wakeup_NoFalseCause)", "posedge sets cause (assert_Wakeup_PosedgeSetsCause)"]
          why: '''The checks sample the pad whatever `EN` is: a pad at 1 before the enable is no rise, a rise just after it is one.'''
          milestone: "V2"
          priority: "1"
          security: false
          state: "open"
        }
        {
          name: REQ_WKUP_13b
          desc: '''The filter shall run while the detector is disabled, so that enabling the detector does not restart it.'''
          source: [
            '''None: the theory of operation and the register description are silent'''
          ]
          kind: "RTL"
          testpoint: "wakeup"
          checks: ["no false cause (assert_Wakeup_NoFalseCause)", "posedge sets cause (assert_Wakeup_PosedgeSetsCause)"]
          why: '''The checks' filter runs whatever `EN` is: a rise whose 4 samples span the enable counts, a pad at 1 before it does not.'''
          milestone: "V2"
          priority: "1"
          security: false
          state: "open"
        }
        {
          name: REQ_WKUP_14
          desc: '''When an enabled detector detects, bit `w` of `WKUP_CAUSE` shall become 1.'''
          source: [
            '''[Wakeup Detectors](hw/top_earlgrey/ip_autogen/pinmux/doc/theory_of_operation.md#wakeup-detectors)'''
            '''!!WKUP_CAUSE.CAUSE'''
            '''[Wakeup Features](hw/top_earlgrey/ip_autogen/pinmux/doc/programmers_guide.md#wakeup-features)'''
            '''[top_earlgrey_pinmux.ipconfig.hjson `n_wkup_detect`](hw/top_earlgrey/ip_autogen/pinmux/data/top_earlgrey_pinmux.ipconfig.hjson)'''
          ]
          kind: "spec"
          testpoint: "wakeup"
          checks: ["posedge sets cause (assert_Wakeup_PosedgeSetsCause)", "negedge sets cause (assert_Wakeup_NegedgeSetsCause)", "edge sets cause (assert_Wakeup_EdgeSetsCause)", "timed high sets cause (assert_Wakeup_TimedHighSetsCause)", "timed low sets cause (assert_Wakeup_TimedLowSetsCause)", "set lands (assert_Wakeup_SetLands)"]
          why: '''Set within 8 cycles; bit 1 a cycle later.'''
          milestone: "V2"
          priority: "1"
          security: false
          state: "open"
        }
        {
          name: REQ_WKUP_15
          desc: '''Bit `w` of `WKUP_CAUSE` shall become 1 only when detector `w` detects.'''
          source: [
            '''!!WKUP_CAUSE.CAUSE'''
            '''[top_earlgrey_pinmux.ipconfig.hjson `n_wkup_detect`](hw/top_earlgrey/ip_autogen/pinmux/data/top_earlgrey_pinmux.ipconfig.hjson)'''
          ]
          kind: "spec"
          testpoint: "wakeup"
          checks: ["no false cause (assert_Wakeup_NoFalseCause)", "cause rises only on a set (assert_Wakeup_CauseRisesOnlyOnASet)"]
          why: '''Only a pattern of detector `w` may set bit `w`, and bit `w` rises only on a set.'''
          milestone: "V2"
          priority: "1"
          security: false
          state: "open"
        }
        {
          name: REQ_WKUP_16
          desc: '''Once 1, a cause bit shall stay 1 until software's clear of it lands, whatever the detector, its enable and the pad do.'''
          source: [
            '''!!WKUP_CAUSE'''
            '''!!WKUP_CAUSE.CAUSE'''
            '''[Wakeup Features](hw/top_earlgrey/ip_autogen/pinmux/doc/programmers_guide.md#wakeup-features)'''
            '''[Wakeup Recording](hw/top_earlgrey/ip_autogen/pwrmgr/doc/theory_of_operation.md#wakeup-recording)'''
          ]
          kind: "spec"
          testpoint: "wakeup_cause"
          checks: ["cause holds until cleared (assert_WakeupCause_CauseHoldsUntilCleared)", "hardware only sets cause (assert_WakeupCause_HardwareOnlySetsCause)"]
          why: '''The bit falls only on a landed clear or at `rst_aon_ni`; hardware writes it 0 only as a clear lands.'''
          milestone: "V2"
          priority: "2"
          security: false
          state: "open"
        }
        {
          name: REQ_WKUP_17
          desc: '''When a detection sets a cause bit in the cycle software's clear of it lands, the bit shall end 0: software's clear wins.'''
          source: [
            '''!!WKUP_CAUSE'''
            '''[Type RW](util/reggen/README.md#type-rw)'''
            '''[Simultaneous SW and HW access](util/reggen/README.md#simultaneous-sw-and-hw-access)'''
          ]
          kind: "spec"
          testpoint: "wakeup_cause"
          checks: ["set and clear together (assert_WakeupCause_SetAndClearTogether)"]
          why: '''When a hardware write of 1 to a cause bit meets a landing clear of that bit, it wants the bit 0 in the next cycle.'''
          milestone: "V2"
          priority: "2"
          security: false
          state: "open"
        }
        {
          name: REQ_WKUP_18a
          desc: '''`pin_wkup_req_o` shall be 1 while at least one cause bit is 1.'''
          source: [
            '''[Inter-Module Signals](hw/top_earlgrey/ip_autogen/pinmux/doc/interfaces.md#inter-module-signals)'''
            '''[Wakeup Detectors](hw/top_earlgrey/ip_autogen/pinmux/doc/theory_of_operation.md#wakeup-detectors)'''
            '''[Wakeup Recording](hw/top_earlgrey/ip_autogen/pwrmgr/doc/theory_of_operation.md#wakeup-recording)'''
            '''[top_earlgrey_pinmux.ipconfig.hjson `n_wkup_detect`](hw/top_earlgrey/ip_autogen/pinmux/data/top_earlgrey_pinmux.ipconfig.hjson)'''
          ]
          kind: "spec"
          testpoint: "wakeup_cause"
          checks: ["request follows cause (assert_WakeupCause_RequestFollowsCause)"]
          why: '''It wants `pin_wkup_req_o` 1 within 2 cycles of any cause bit rising, and while any has held 1 for 3 cycles in a row.'''
          milestone: "V2"
          priority: "2"
          security: false
          state: "open"
        }
        {
          name: REQ_WKUP_18b
          desc: '''`pin_wkup_req_o` shall be 0 while every cause bit is 0.'''
          source: [
            '''[Inter-Module Signals](hw/top_earlgrey/ip_autogen/pinmux/doc/interfaces.md#inter-module-signals)'''
            '''[Wakeup Detectors](hw/top_earlgrey/ip_autogen/pinmux/doc/theory_of_operation.md#wakeup-detectors)'''
            '''[Wakeup Recording](hw/top_earlgrey/ip_autogen/pwrmgr/doc/theory_of_operation.md#wakeup-recording)'''
            '''[top_earlgrey_pinmux.ipconfig.hjson `n_wkup_detect`](hw/top_earlgrey/ip_autogen/pinmux/data/top_earlgrey_pinmux.ipconfig.hjson)'''
          ]
          kind: "spec"
          testpoint: "wakeup_cause"
          checks: ["no request without cause (assert_WakeupCause_NoRequestWithoutCause)"]
          why: '''It wants `pin_wkup_req_o` 0 once every cause bit has been 0 for 3 cycles in a row.'''
          milestone: "V2"
          priority: "2"
          security: false
          state: "open"
        }
        {
          name: REQ_WKUP_19a
          desc: '''A write to a detector's enable shall reach the AON logic within a bounded time.'''
          source: [
            '''!!WKUP_DETECTOR_EN'''
            '''!!WKUP_DETECTOR'''
            '''!!WKUP_DETECTOR_CNT_TH'''
            '''!!WKUP_CAUSE'''
            '''[Wakeup Features](hw/top_earlgrey/ip_autogen/pinmux/doc/programmers_guide.md#wakeup-features)'''
          ]
          kind: "spec"
          testpoint: "wakeup_sync"
          checks: ["write lands (assert_WakeupSync_WriteLands)", "no change without a write (assert_WakeupSync_NoChangeWithoutAWrite)"]
          why: '''For `EN`, each accepted write lands within 4 cycles, and only a write not yet landed changes the field.'''
          milestone: "V2"
          priority: "2"
          security: false
          state: "open"
        }
        {
          name: REQ_WKUP_19b
          desc: '''A write to a detector's configuration shall reach the AON logic within a bounded time.'''
          source: [
            '''!!WKUP_DETECTOR_EN'''
            '''!!WKUP_DETECTOR'''
            '''!!WKUP_DETECTOR_CNT_TH'''
            '''!!WKUP_CAUSE'''
            '''[Wakeup Features](hw/top_earlgrey/ip_autogen/pinmux/doc/programmers_guide.md#wakeup-features)'''
          ]
          kind: "spec"
          testpoint: "wakeup_sync"
          checks: ["write lands (assert_WakeupSync_WriteLands)", "no change without a write (assert_WakeupSync_NoChangeWithoutAWrite)"]
          why: '''For `MODE`, `FILTER` and `MIODIO`, each accepted write lands within 4 cycles and only a write not yet landed changes one.'''
          milestone: "V2"
          priority: "2"
          security: false
          state: "open"
        }
        {
          name: REQ_WKUP_19c
          desc: '''A write to a detector's threshold shall reach the AON logic within a bounded time.'''
          source: [
            '''!!WKUP_DETECTOR_EN'''
            '''!!WKUP_DETECTOR'''
            '''!!WKUP_DETECTOR_CNT_TH'''
            '''!!WKUP_CAUSE'''
            '''[Wakeup Features](hw/top_earlgrey/ip_autogen/pinmux/doc/programmers_guide.md#wakeup-features)'''
          ]
          kind: "spec"
          testpoint: "wakeup_sync"
          checks: ["write lands (assert_WakeupSync_WriteLands)", "no change without a write (assert_WakeupSync_NoChangeWithoutAWrite)"]
          why: '''For `CNT_TH`, each accepted write lands within 4 cycles, and only a write not yet landed changes the field.'''
          milestone: "V2"
          priority: "2"
          security: false
          state: "open"
        }
        {
          name: REQ_WKUP_19d
          desc: '''A clear of `WKUP_CAUSE` shall reach the AON logic within a bounded time.'''
          source: [
            '''!!WKUP_DETECTOR_EN'''
            '''!!WKUP_DETECTOR'''
            '''!!WKUP_DETECTOR_CNT_TH'''
            '''!!WKUP_CAUSE'''
            '''[Wakeup Features](hw/top_earlgrey/ip_autogen/pinmux/doc/programmers_guide.md#wakeup-features)'''
          ]
          kind: "spec"
          testpoint: "wakeup_sync"
          checks: ["clear lands (assert_WakeupSync_ClearLands)", "landed clear clears cause (assert_WakeupSync_LandedClearClearsCause)", "no clear without a write (assert_WakeupSync_NoClearWithoutAWrite)"]
          why: '''A clear lands within 10 cycles, the bit 0 a cycle later; none lands without a write.'''
          milestone: "V2"
          priority: "2"
          security: false
          state: "open"
        }
        {
          name: REQ_WKUP_20a
          desc: '''A write to a detector's *configuration* accepted before a write to its enable shall hold in the AON logic no later than that enable write.'''
          source: [
            '''!!WKUP_DETECTOR_EN'''
          ]
          kind: "spec"
          testpoint: "wakeup_sync"
          checks: ["writes land in order (assert_WakeupSync_WritesLandInOrder)"]
          why: '''It compares the AON cycles in which a configuration write and a later enable write land: the enable may not land first.'''
          milestone: "V2"
          priority: "2"
          security: false
          state: "open"
        }
        {
          name: REQ_WKUP_20b
          desc: '''A write to a detector's *threshold* accepted before a write to its enable shall hold in the AON logic no later than that enable write.'''
          source: [
            '''!!WKUP_DETECTOR_EN'''
          ]
          kind: "spec"
          testpoint: "wakeup_sync"
          checks: ["writes land in order (assert_WakeupSync_WritesLandInOrder)"]
          why: '''It compares the AON cycles in which a threshold write and a later enable write land: an enable that holds before the threshold fails it.'''
          milestone: "V2"
          priority: "2"
          security: false
          state: "open"
        }
      ]
    }
    {
      name: '''USB wakeup'''
      conditions: [
        '''the module is usbdev's AON/Wake module ([USB Wakeup Detection Module](hw/top_earlgrey/ip_autogen/pinmux/doc/theory_of_operation.md#usb-wakeup-detection-module)); each port below has the role usbdev's docs give the port it connects to:'''
        '''`usbdev_dppullup_en`: D+ pull-up enable, routed to the module's input `usbdev_dppullup_en_i` ([AON/Wake Interface Pins](hw/ip/usbdev/doc/theory_of_operation.md#aonwake-interface-pins))'''
        '''`usbdev_dnpullup_en`: D- pull-up enable, routed to the module's input `usbdev_dnpullup_en_i` ([AON/Wake Interface Pins](hw/ip/usbdev/doc/theory_of_operation.md#aonwake-interface-pins))'''
        '''`usbdev_suspend_req`: "Request to activate the AON/Wake module" ([Inter-Module Signals](hw/ip/usbdev/doc/interfaces.md#inter-module-signals))'''
        '''`usbdev_wake_ack`: "Acknowledge a wake signal from the AON/Wake" ([Inter-Module Signals](hw/ip/usbdev/doc/interfaces.md#inter-module-signals))'''
        '''`usb_dppullup_en`: D+ pull-up enable from the module's output `usb_dppullup_en_o` ([AON/Wake Interface Pins](hw/ip/usbdev/doc/theory_of_operation.md#aonwake-interface-pins))'''
        '''`usb_dnpullup_en`: D- pull-up enable from the module's output `usb_dnpullup_en_o` ([AON/Wake Interface Pins](hw/ip/usbdev/doc/theory_of_operation.md#aonwake-interface-pins))'''
        '''`usbdev_bus_not_idle`: The event "the USB is in a non-idle state" ([Inter-Module Signals](hw/ip/usbdev/doc/interfaces.md#inter-module-signals))'''
        '''`usbdev_bus_reset`: The event "a USB Bus Reset occurred" ([Inter-Module Signals](hw/ip/usbdev/doc/interfaces.md#inter-module-signals))'''
        '''`usbdev_sense_lost`: The event "the VBUS/SENSE signal became deasserted" ([Inter-Module Signals](hw/ip/usbdev/doc/interfaces.md#inter-module-signals))'''
        '''`usbdev_wake_detect_active`: "the external AON/Wake module is active" ([Inter-Module Signals](hw/ip/usbdev/doc/interfaces.md#inter-module-signals)): the module's output `wake_detect_active_aon_o` ([AON/Wake Interface Pins](hw/ip/usbdev/doc/theory_of_operation.md#aonwake-interface-pins))'''
        '''A suspend request is a `clk_aon_i` cycle with `usbdev_suspend_req` at 1, a wake acknowledge one with `usbdev_wake_ack` at 1.'''
        '''The USB lines are the module's D+, D- and VBUS inputs, free at any time; the module is active while `usbdev_wake_detect_active` is 1.'''
        '''Idle (J state) is, with one pad pull-up enable at 1, that line at 1 and the other at 0; with none or both, the bus-not-idle event is not checked.'''
        '''The two pull-up rows hold with usbdev's pull-up enables unchanged just before the suspend request.'''
        '''The wiring rows follow usbdev's documents; the pinmux theory of operation names only `usb_wkup_req` ([USB Wakeup Detection Module](hw/top_earlgrey/ip_autogen/pinmux/doc/theory_of_operation.md#usb-wakeup-detection-module)).'''
      ]
      requirements: [
        {
          name: REQ_USB_01a
          desc: '''`usbdev_dppullup_en` shall reach the module's input of the same role unchanged, in the same cycle.'''
          source: [
            '''[Inter-Module Signals](hw/top_earlgrey/ip_autogen/pinmux/doc/interfaces.md#inter-module-signals)'''
            '''[top_earlgrey.hjson `inter_module.connect usbdev.usb_dp_pullup`](hw/top_earlgrey/data/top_earlgrey.hjson)'''
            '''[top_earlgrey_pinmux.ipconfig.hjson `enable_usb_wakeup`](hw/top_earlgrey/ip_autogen/pinmux/data/top_earlgrey_pinmux.ipconfig.hjson)'''
          ]
          kind: "spec"
          testpoint: "usb_conn"
          checks: ["D+ pull-up enable in (assert_UsbConn_DpPullUpEnableIn)"]
          why: '''It compares the module's `usbdev_dppullup_en_i` port with `usbdev_dppullup_en` in every cycle.'''
          milestone: "V2"
          priority: "2"
          security: false
          state: "open"
        }
        {
          name: REQ_USB_01b
          desc: '''`usbdev_dnpullup_en` shall reach the module's input of the same role unchanged, in the same cycle.'''
          source: [
            '''[Inter-Module Signals](hw/top_earlgrey/ip_autogen/pinmux/doc/interfaces.md#inter-module-signals)'''
            '''[top_earlgrey.hjson `inter_module.connect usbdev.usb_dn_pullup`](hw/top_earlgrey/data/top_earlgrey.hjson)'''
            '''[top_earlgrey_pinmux.ipconfig.hjson `enable_usb_wakeup`](hw/top_earlgrey/ip_autogen/pinmux/data/top_earlgrey_pinmux.ipconfig.hjson)'''
          ]
          kind: "spec"
          testpoint: "usb_conn"
          checks: ["D- pull-up enable in (assert_UsbConn_DnPullUpEnableIn)"]
          why: '''It compares the module's `usbdev_dnpullup_en_i` port with `usbdev_dnpullup_en` in every cycle.'''
          milestone: "V2"
          priority: "2"
          security: false
          state: "open"
        }
        {
          name: REQ_USB_01c
          desc: '''`usbdev_suspend_req` shall reach the module's input of the same role unchanged, in the same cycle.'''
          source: [
            '''[Inter-Module Signals](hw/top_earlgrey/ip_autogen/pinmux/doc/interfaces.md#inter-module-signals)'''
            '''[top_earlgrey.hjson `inter_module.connect usbdev.usb_aon_suspend_req`](hw/top_earlgrey/data/top_earlgrey.hjson)'''
            '''[top_earlgrey_pinmux.ipconfig.hjson `enable_usb_wakeup`](hw/top_earlgrey/ip_autogen/pinmux/data/top_earlgrey_pinmux.ipconfig.hjson)'''
          ]
          kind: "spec"
          testpoint: "usb_conn"
          checks: ["suspend request in (assert_UsbConn_SuspendRequestIn)"]
          why: '''It compares the module's suspend request port with `usbdev_suspend_req` in every cycle, a one-cycle pulse included.'''
          milestone: "V2"
          priority: "2"
          security: false
          state: "open"
        }
        {
          name: REQ_USB_01d
          desc: '''`usbdev_wake_ack` shall reach the module's input of the same role unchanged, in the same cycle.'''
          source: [
            '''[Inter-Module Signals](hw/top_earlgrey/ip_autogen/pinmux/doc/interfaces.md#inter-module-signals)'''
            '''[top_earlgrey.hjson `inter_module.connect usbdev.usb_aon_wake_ack`](hw/top_earlgrey/data/top_earlgrey.hjson)'''
            '''[top_earlgrey_pinmux.ipconfig.hjson `enable_usb_wakeup`](hw/top_earlgrey/ip_autogen/pinmux/data/top_earlgrey_pinmux.ipconfig.hjson)'''
          ]
          kind: "spec"
          testpoint: "usb_conn"
          checks: ["wake acknowledge in (assert_UsbConn_WakeAcknowledgeIn)"]
          why: '''It compares the module's wake acknowledge port with `usbdev_wake_ack` in every cycle.'''
          milestone: "V2"
          priority: "2"
          security: false
          state: "open"
        }
        {
          name: REQ_USB_02a
          desc: '''The module's pull-up enable of the same role shall reach `usb_dppullup_en` unchanged, in the same cycle.'''
          source: [
            '''[Inter-Module Signals](hw/top_earlgrey/ip_autogen/pinmux/doc/interfaces.md#inter-module-signals)'''
            '''[top_earlgrey.hjson `inter_module.external pinmux.usb_dppullup_en`](hw/top_earlgrey/data/top_earlgrey.hjson)'''
            '''[top_earlgrey_pinmux.ipconfig.hjson `enable_usb_wakeup`](hw/top_earlgrey/ip_autogen/pinmux/data/top_earlgrey_pinmux.ipconfig.hjson)'''
          ]
          kind: "spec"
          testpoint: "usb_conn"
          checks: ["D+ pull-up enable out (assert_UsbConn_DpPullUpEnableOut)"]
          why: '''It compares `usb_dppullup_en` with the module's `usb_dppullup_en_o` port in every cycle.'''
          milestone: "V2"
          priority: "2"
          security: false
          state: "open"
        }
        {
          name: REQ_USB_02b
          desc: '''The module's pull-up enable of the same role shall reach `usb_dnpullup_en` unchanged, in the same cycle.'''
          source: [
            '''[Inter-Module Signals](hw/top_earlgrey/ip_autogen/pinmux/doc/interfaces.md#inter-module-signals)'''
            '''[top_earlgrey.hjson `inter_module.external pinmux.usb_dnpullup_en`](hw/top_earlgrey/data/top_earlgrey.hjson)'''
            '''[top_earlgrey_pinmux.ipconfig.hjson `enable_usb_wakeup`](hw/top_earlgrey/ip_autogen/pinmux/data/top_earlgrey_pinmux.ipconfig.hjson)'''
          ]
          kind: "spec"
          testpoint: "usb_conn"
          checks: ["D- pull-up enable out (assert_UsbConn_DnPullUpEnableOut)"]
          why: '''It compares `usb_dnpullup_en` with the module's `usb_dnpullup_en_o` port in every cycle.'''
          milestone: "V2"
          priority: "2"
          security: false
          state: "open"
        }
        {
          name: REQ_USB_02c
          desc: '''The module's event of the same role, one of its three events, shall reach `usbdev_bus_not_idle` unchanged, in the same cycle.'''
          source: [
            '''[Inter-Module Signals](hw/top_earlgrey/ip_autogen/pinmux/doc/interfaces.md#inter-module-signals)'''
            '''[top_earlgrey.hjson `inter_module.connect usbdev.usb_aon_bus_not_idle`](hw/top_earlgrey/data/top_earlgrey.hjson)'''
            '''[top_earlgrey_pinmux.ipconfig.hjson `enable_usb_wakeup`](hw/top_earlgrey/ip_autogen/pinmux/data/top_earlgrey_pinmux.ipconfig.hjson)'''
          ]
          kind: "spec"
          testpoint: "usb_conn"
          checks: ["bus not idle out (assert_UsbConn_BusNotIdleOut)"]
          why: '''It compares `usbdev_bus_not_idle` with the module's resume event port in every cycle.'''
          milestone: "V2"
          priority: "2"
          security: false
          state: "open"
        }
        {
          name: REQ_USB_02d
          desc: '''The module's event of the same role, one of its three events, shall reach `usbdev_bus_reset` unchanged, in the same cycle.'''
          source: [
            '''[Inter-Module Signals](hw/top_earlgrey/ip_autogen/pinmux/doc/interfaces.md#inter-module-signals)'''
            '''[top_earlgrey.hjson `inter_module.connect usbdev.usb_aon_bus_reset`](hw/top_earlgrey/data/top_earlgrey.hjson)'''
            '''[top_earlgrey_pinmux.ipconfig.hjson `enable_usb_wakeup`](hw/top_earlgrey/ip_autogen/pinmux/data/top_earlgrey_pinmux.ipconfig.hjson)'''
          ]
          kind: "spec"
          testpoint: "usb_conn"
          checks: ["bus reset out (assert_UsbConn_BusResetOut)"]
          why: '''It compares `usbdev_bus_reset` with the module's bus reset event port in every cycle.'''
          milestone: "V2"
          priority: "2"
          security: false
          state: "open"
        }
        {
          name: REQ_USB_02e
          desc: '''The module's event of the same role, one of its three events, shall reach `usbdev_sense_lost` unchanged, in the same cycle.'''
          source: [
            '''[Inter-Module Signals](hw/top_earlgrey/ip_autogen/pinmux/doc/interfaces.md#inter-module-signals)'''
            '''[top_earlgrey.hjson `inter_module.connect usbdev.usb_aon_sense_lost`](hw/top_earlgrey/data/top_earlgrey.hjson)'''
            '''[top_earlgrey_pinmux.ipconfig.hjson `enable_usb_wakeup`](hw/top_earlgrey/ip_autogen/pinmux/data/top_earlgrey_pinmux.ipconfig.hjson)'''
          ]
          kind: "spec"
          testpoint: "usb_conn"
          checks: ["sense lost out (assert_UsbConn_SenseLostOut)"]
          why: '''It compares `usbdev_sense_lost` with the module's VBUS lost event port in every cycle.'''
          milestone: "V2"
          priority: "2"
          security: false
          state: "open"
        }
        {
          name: REQ_USB_02f
          desc: '''The module's active state shall reach `usbdev_wake_detect_active` unchanged, in the same cycle.'''
          source: [
            '''[Inter-Module Signals](hw/top_earlgrey/ip_autogen/pinmux/doc/interfaces.md#inter-module-signals)'''
            '''[top_earlgrey.hjson `inter_module.connect pinmux.usbdev_wake_detect_active`](hw/top_earlgrey/data/top_earlgrey.hjson)'''
            '''[top_earlgrey_pinmux.ipconfig.hjson `enable_usb_wakeup`](hw/top_earlgrey/ip_autogen/pinmux/data/top_earlgrey_pinmux.ipconfig.hjson)'''
          ]
          kind: "spec"
          testpoint: "usb_conn"
          checks: ["active out (assert_UsbConn_ActiveOut)"]
          why: '''It compares `usbdev_wake_detect_active` with the module's `wake_detect_active_aon_o` port in every cycle: a value from another port, or delayed, fails it.'''
          milestone: "V2"
          priority: "2"
          security: false
          state: "open"
        }
        {
          name: REQ_USB_03
          desc: '''`usb_wkup_req` shall be the module's wake request, unchanged, in the same cycle.'''
          source: [
            '''[Inter-Module Signals](hw/top_earlgrey/ip_autogen/pinmux/doc/interfaces.md#inter-module-signals)'''
            '''[top_earlgrey_pinmux.ipconfig.hjson `enable_usb_wakeup`](hw/top_earlgrey/ip_autogen/pinmux/data/top_earlgrey_pinmux.ipconfig.hjson)'''
          ]
          kind: "spec"
          testpoint: "usb_conn"
          checks: ["wake request out (assert_UsbConn_WakeRequestOut)"]
          why: '''It compares `usb_wkup_req` with the module's `wake_req_aon_o` port in every cycle, a one-cycle pulse included.'''
          milestone: "V2"
          priority: "2"
          security: false
          state: "open"
        }
        {
          name: REQ_USB_04a
          desc: '''The module shall run on `clk_aon_i`.'''
          source: [
            '''[Inter-Module Signals](hw/top_earlgrey/ip_autogen/pinmux/doc/interfaces.md#inter-module-signals)'''
            '''[USB Wakeup Detection Module](hw/top_earlgrey/ip_autogen/pinmux/doc/theory_of_operation.md#usb-wakeup-detection-module)'''
            '''[AON/Wake Clocking](hw/ip/usbdev/doc/theory_of_operation.md#aonwake-clocking)'''
            '''[top_earlgrey_pinmux.ipconfig.hjson `enable_usb_wakeup`](hw/top_earlgrey/ip_autogen/pinmux/data/top_earlgrey_pinmux.ipconfig.hjson)'''
          ]
          kind: "spec"
          testpoint: "usb_conn"
          checks: ["module on AON clock (assert_UsbConn_ModuleOnAonClock)"]
          why: '''It compares the module's clock with `clk_aon_i` in every cycle; the run clocks `clk_aon_i` slower than `clk_i`, so a module on `clk_i` fails it.'''
          milestone: "V2"
          priority: "2"
          security: false
          state: "open"
        }
        {
          name: REQ_USB_04b
          desc: '''The module shall be reset by `rst_aon_ni`.'''
          source: [
            '''[pinmux.hjson `clocking`](hw/top_earlgrey/ip_autogen/pinmux/data/pinmux.hjson)'''
            '''[top_earlgrey_pinmux.ipconfig.hjson `enable_usb_wakeup`](hw/top_earlgrey/ip_autogen/pinmux/data/top_earlgrey_pinmux.ipconfig.hjson)'''
            '''[AON/Wake Clocking](hw/ip/usbdev/doc/theory_of_operation.md#aonwake-clocking)'''
          ]
          kind: "spec"
          testpoint: "usb_conn"
          checks: ["module on AON reset (check_UsbConn_ModuleOnAonReset)"]
          why: '''It fails on any flop of the module whose reset pin `rst_aon_ni` does not drive.'''
          milestone: "V2"
          priority: "2"
          security: false
          state: "open"
        }
        {
          name: REQ_USB_05a
          desc: '''The module's D+ input shall be usbdev's input as the pinmux delivers it: the DIO pad USB_P.'''
          source: [
            '''[AON/Wake Interface Pins](hw/ip/usbdev/doc/theory_of_operation.md#aonwake-interface-pins)'''
            '''[top_earlgrey.hjson `pinout.pads USB_P`](hw/top_earlgrey/data/top_earlgrey.hjson)'''
            '''[top_earlgrey.hjson `pinmux`](hw/top_earlgrey/data/top_earlgrey.hjson)'''
            '''[top_earlgrey.hjson `pinmux.signals`](hw/top_earlgrey/data/top_earlgrey.hjson)'''
            '''[top_earlgrey_pinmux.ipconfig.hjson `enable_usb_wakeup`](hw/top_earlgrey/ip_autogen/pinmux/data/top_earlgrey_pinmux.ipconfig.hjson)'''
          ]
          kind: "spec"
          testpoint: "usb_conn"
          checks: ["bus inputs (assert_UsbConn_BusInputs)"]
          why: '''It compares the module's D+ input with the DIO pad USB_P in every cycle: an input taken from USB_N or another pad, or through a flop, fails it.'''
          milestone: "V2"
          priority: "2"
          security: false
          state: "open"
        }
        {
          name: REQ_USB_05b
          desc: '''The module's D- input shall be usbdev's input as the pinmux delivers it: the DIO pad USB_N.'''
          source: [
            '''[AON/Wake Interface Pins](hw/ip/usbdev/doc/theory_of_operation.md#aonwake-interface-pins)'''
            '''[top_earlgrey.hjson `pinout.pads USB_N`](hw/top_earlgrey/data/top_earlgrey.hjson)'''
            '''[top_earlgrey.hjson `pinmux`](hw/top_earlgrey/data/top_earlgrey.hjson)'''
            '''[top_earlgrey.hjson `pinmux.signals`](hw/top_earlgrey/data/top_earlgrey.hjson)'''
            '''[top_earlgrey_pinmux.ipconfig.hjson `enable_usb_wakeup`](hw/top_earlgrey/ip_autogen/pinmux/data/top_earlgrey_pinmux.ipconfig.hjson)'''
          ]
          kind: "spec"
          testpoint: "usb_conn"
          checks: ["bus inputs (assert_UsbConn_BusInputs)"]
          why: '''It compares the module's D- input with the DIO pad USB_N in every cycle: an input taken from USB_P or another pad, or through a flop, fails it.'''
          milestone: "V2"
          priority: "2"
          security: false
          state: "open"
        }
        {
          name: REQ_USB_05c
          desc: '''The module's VBUS input shall be usbdev's input as the pinmux delivers it: the muxed input `sense` after its input select.'''
          source: [
            '''[AON/Wake Interface Pins](hw/ip/usbdev/doc/theory_of_operation.md#aonwake-interface-pins)'''
            '''[top_earlgrey.hjson `pinmux`](hw/top_earlgrey/data/top_earlgrey.hjson)'''
            '''[top_earlgrey.hjson `pinmux.signals`](hw/top_earlgrey/data/top_earlgrey.hjson)'''
            '''[top_earlgrey_pinmux.ipconfig.hjson `enable_usb_wakeup`](hw/top_earlgrey/ip_autogen/pinmux/data/top_earlgrey_pinmux.ipconfig.hjson)'''
          ]
          kind: "spec"
          testpoint: "usb_conn"
          checks: ["bus inputs (assert_UsbConn_BusInputs)"]
          why: '''It compares the module's VBUS input with usbdev's sense input after its input select in every cycle.'''
          milestone: "V2"
          priority: "2"
          security: false
          state: "open"
        }
        {
          name: REQ_USB_06a
          desc: '''While the module is inactive, a suspend request shall make it active within a bounded time.'''
          source: [
            '''[Suspending](hw/ip/usbdev/doc/wake_resume.md#suspending)'''
            '''[usbdev.hjson `wake_control.suspend_req`](hw/ip/usbdev/data/usbdev.hjson)'''
            '''[Inter-Module Signals](hw/ip/usbdev/doc/interfaces.md#inter-module-signals)'''
            '''[top_earlgrey_pinmux.ipconfig.hjson `enable_usb_wakeup`](hw/top_earlgrey/ip_autogen/pinmux/data/top_earlgrey_pinmux.ipconfig.hjson)'''
          ]
          kind: "spec"
          testpoint: "usb_module"
          checks: ["request activates (assert_UsbModule_RequestActivates)"]
          why: '''It wants `usbdev_wake_detect_active` 1 within 2 AON clock cycles of each suspend request while inactive.'''
          milestone: "V2"
          priority: "2"
          security: false
          state: "open"
        }
        {
          name: REQ_USB_06b
          desc: '''While the module is active, a wake acknowledge shall make it inactive within a bounded time.'''
          source: [
            '''[Resuming](hw/ip/usbdev/doc/wake_resume.md#resuming)'''
            '''[usbdev.hjson `wake_control.wake_ack`](hw/ip/usbdev/data/usbdev.hjson)'''
            '''[Inter-Module Signals](hw/ip/usbdev/doc/interfaces.md#inter-module-signals)'''
            '''[Inter-Module Signals](hw/top_earlgrey/ip_autogen/pinmux/doc/interfaces.md#inter-module-signals)'''
            '''[top_earlgrey_pinmux.ipconfig.hjson `enable_usb_wakeup`](hw/top_earlgrey/ip_autogen/pinmux/data/top_earlgrey_pinmux.ipconfig.hjson)'''
          ]
          kind: "spec"
          testpoint: "usb_module"
          checks: ["acknowledge releases (assert_UsbModule_AcknowledgeReleases)"]
          why: '''It wants `usbdev_wake_detect_active` 0 within 2 AON clock cycles of each wake acknowledge while active.'''
          milestone: "V2"
          priority: "2"
          security: false
          state: "open"
        }
        {
          name: REQ_USB_06c
          desc: '''Apart from a suspend request made while it is inactive and a wake acknowledge made while it is active, nothing shall change whether the module is active.'''
          source: [
            '''[Suspending](hw/ip/usbdev/doc/wake_resume.md#suspending)'''
            '''[Resuming](hw/ip/usbdev/doc/wake_resume.md#resuming)'''
            '''[usbdev.hjson `wake_control.suspend_req`](hw/ip/usbdev/data/usbdev.hjson)'''
            '''[usbdev.hjson `wake_control.wake_ack`](hw/ip/usbdev/data/usbdev.hjson)'''
            '''[Inter-Module Signals](hw/ip/usbdev/doc/interfaces.md#inter-module-signals)'''
            '''[top_earlgrey_pinmux.ipconfig.hjson `enable_usb_wakeup`](hw/top_earlgrey/ip_autogen/pinmux/data/top_earlgrey_pinmux.ipconfig.hjson)'''
          ]
          kind: "spec"
          testpoint: "usb_module"
          checks: ["no other state change (assert_UsbModule_NoOtherStateChange)"]
          why: '''It lets `usbdev_wake_detect_active` rise only after a suspend request and fall only after a wake acknowledge.'''
          milestone: "V2"
          priority: "2"
          security: false
          state: "open"
        }
        {
          name: REQ_USB_06d
          desc: '''While the module is inactive, each pad pull-up enable (`usb_dppullup_en`, `usb_dnpullup_en`) shall equal usbdev's enable of the same line in the same cycle.'''
          source: [
            '''[AON/Wake Interface Pins](hw/ip/usbdev/doc/theory_of_operation.md#aonwake-interface-pins)'''
            '''[Resuming](hw/ip/usbdev/doc/wake_resume.md#resuming)'''
            '''[usbdev.hjson `wake_control.wake_ack`](hw/ip/usbdev/data/usbdev.hjson)'''
            '''[Inter-Module Signals](hw/top_earlgrey/ip_autogen/pinmux/doc/interfaces.md#inter-module-signals)'''
            '''[top_earlgrey_pinmux.ipconfig.hjson `enable_usb_wakeup`](hw/top_earlgrey/ip_autogen/pinmux/data/top_earlgrey_pinmux.ipconfig.hjson)'''
          ]
          kind: "spec"
          testpoint: "usb_module"
          checks: ["inactive passes pull-ups (assert_UsbModule_InactivePassesPullUps)"]
          why: '''It compares each pull-up enable to the pads with usbdev's enable of its line while the module is inactive.'''
          milestone: "V2"
          priority: "2"
          security: false
          state: "open"
        }
        {
          name: REQ_USB_06e
          desc: '''With the module active and `usbdev_sense_lost` at 0, each pad pull-up enable shall keep usbdev's enable of its line at the activating suspend request.'''
          source: [
            '''[Overview](hw/ip/usbdev/doc/wake_resume.md#overview)'''
            '''[Inter-Module Signals](hw/top_earlgrey/ip_autogen/pinmux/doc/interfaces.md#inter-module-signals)'''
            '''[chip_usbdev_testplan.hjson `chip_sw_usbdev_aon_pullup`](hw/top_earlgrey/data/ip/chip_usbdev_testplan.hjson)'''
            '''[top_earlgrey_pinmux.ipconfig.hjson `enable_usb_wakeup`](hw/top_earlgrey/ip_autogen/pinmux/data/top_earlgrey_pinmux.ipconfig.hjson)'''
          ]
          kind: "spec"
          testpoint: "usb_module"
          checks: ["active holds pull-ups (assert_UsbModule_ActiveHoldsPullUps)", "waits: pull-ups after VBUS loss"]
          why: '''It wants each pull-up enable at usbdev's value at the suspend request while `usbdev_sense_lost` is 0.'''
          milestone: "V2"
          priority: "2"
          security: false
          state: "open"
        }
        {
          name: REQ_USB_06f
          desc: '''While the module is active, each held condition shall set its event within a bounded time: bus not idle, bus reset (D+ and D- low), sense lost (VBUS low).'''
          source: [
            '''[Optional external AON/Wake functionality](hw/ip/usbdev/doc/theory_of_operation.md#optional-external-aonwake-functionality)'''
            '''[AON/Wake Clocking](hw/ip/usbdev/doc/theory_of_operation.md#aonwake-clocking)'''
            '''[usbdev.hjson `wake_events.disconnected`](hw/ip/usbdev/data/usbdev.hjson)'''
            '''[usbdev.hjson `wake_events.bus_reset`](hw/ip/usbdev/data/usbdev.hjson)'''
            '''[usbdev.hjson `wake_events.bus_not_idle`](hw/ip/usbdev/data/usbdev.hjson)'''
            '''[Inter-Module Signals](hw/ip/usbdev/doc/interfaces.md#inter-module-signals)'''
            '''[Inter-Module Signals](hw/top_earlgrey/ip_autogen/pinmux/doc/interfaces.md#inter-module-signals)'''
            '''[usbdev_testplan.hjson `aon_wake_resume`](hw/ip/usbdev/data/usbdev_testplan.hjson)'''
            '''[usbdev_testplan.hjson `aon_wake_reset`](hw/ip/usbdev/data/usbdev_testplan.hjson)'''
            '''[usbdev_testplan.hjson `aon_wake_disconnect`](hw/ip/usbdev/data/usbdev_testplan.hjson)'''
            '''[top_earlgrey_pinmux.ipconfig.hjson `enable_usb_wakeup`](hw/top_earlgrey/ip_autogen/pinmux/data/top_earlgrey_pinmux.ipconfig.hjson)'''
          ]
          kind: "spec"
          testpoint: "usb_module"
          checks: ["held condition sets event (assert_UsbModule_HeldConditionSetsEvent)"]
          why: '''It wants each event at 1 once its condition has been on the lines in a cycle and the 8 after it.'''
          milestone: "V2"
          priority: "2"
          security: false
          state: "open"
        }
        {
          name: REQ_USB_06g
          desc: '''An event shall be set only after its own condition was on the USB lines while the module was active, for at least the shortest time the module must report.'''
          source: [
            '''[usbdev.hjson `wake_events.disconnected`](hw/ip/usbdev/data/usbdev.hjson)'''
            '''[usbdev.hjson `wake_events.bus_reset`](hw/ip/usbdev/data/usbdev.hjson)'''
            '''[usbdev.hjson `wake_events.bus_not_idle`](hw/ip/usbdev/data/usbdev.hjson)'''
            '''[Inter-Module Signals](hw/top_earlgrey/ip_autogen/pinmux/doc/interfaces.md#inter-module-signals)'''
            '''[AON/Wake Clocking](hw/ip/usbdev/doc/theory_of_operation.md#aonwake-clocking)'''
            '''[top_earlgrey_pinmux.ipconfig.hjson `enable_usb_wakeup`](hw/top_earlgrey/ip_autogen/pinmux/data/top_earlgrey_pinmux.ipconfig.hjson)'''
          ]
          kind: "spec"
          testpoint: "usb_module"
          checks: ["event only after its condition (assert_UsbModule_EventOnlyAfterItsCondition)", "waits: short condition sets no event"]
          why: '''It lets an event rise only on its own condition, seen with the module active from then on.'''
          milestone: "V2"
          priority: "2"
          security: false
          state: "open"
        }
        {
          name: REQ_USB_06h
          desc: '''An event, once set, shall stay set for as long as the module stays active.'''
          source: [
            '''[Resuming](hw/ip/usbdev/doc/wake_resume.md#resuming)'''
            '''[Inter-Module Signals](hw/ip/usbdev/doc/interfaces.md#inter-module-signals)'''
            '''[top_earlgrey_pinmux.ipconfig.hjson `enable_usb_wakeup`](hw/top_earlgrey/ip_autogen/pinmux/data/top_earlgrey_pinmux.ipconfig.hjson)'''
          ]
          kind: "spec"
          testpoint: "usb_module"
          checks: ["event holds while active (assert_UsbModule_EventHoldsWhileActive)"]
          why: '''It wants an event at 1 to stay 1 in the next cycle while the module stays active, whatever the USB lines do.'''
          milestone: "V2"
          priority: "2"
          security: false
          state: "open"
        }
        {
          name: REQ_USB_06i
          desc: '''A wake acknowledge made while the module is active shall clear each of the three events within a bounded time.'''
          source: [
            '''[Resuming](hw/ip/usbdev/doc/wake_resume.md#resuming)'''
            '''[Inter-Module Signals](hw/top_earlgrey/ip_autogen/pinmux/doc/interfaces.md#inter-module-signals)'''
            '''[top_earlgrey_pinmux.ipconfig.hjson `enable_usb_wakeup`](hw/top_earlgrey/ip_autogen/pinmux/data/top_earlgrey_pinmux.ipconfig.hjson)'''
          ]
          kind: "spec"
          testpoint: "usb_module"
          checks: ["acknowledge clears events (assert_UsbModule_AcknowledgeClearsEvents)"]
          why: '''It wants each of the three events at 0 in one of the 4 AON clock cycles after each wake acknowledge while active.'''
          milestone: "V2"
          priority: "2"
          security: false
          state: "open"
        }
        {
          name: REQ_USB_06j
          desc: '''The module's wake request shall be 1 exactly while at least one of its three events is set.'''
          source: [
            '''[Overview](hw/ip/usbdev/doc/wake_resume.md#overview)'''
            '''[usbdev_testplan.hjson `aon_wake_resume`](hw/ip/usbdev/data/usbdev_testplan.hjson)'''
            '''[usbdev_testplan.hjson `aon_wake_reset`](hw/ip/usbdev/data/usbdev_testplan.hjson)'''
            '''[usbdev_testplan.hjson `aon_wake_disconnect`](hw/ip/usbdev/data/usbdev_testplan.hjson)'''
            '''[Inter-Module Signals](hw/ip/usbdev/doc/interfaces.md#inter-module-signals)'''
            '''[Inter-Module Signals](hw/top_earlgrey/ip_autogen/pinmux/doc/interfaces.md#inter-module-signals)'''
            '''[Wakeup Recording](hw/top_earlgrey/ip_autogen/pwrmgr/doc/theory_of_operation.md#wakeup-recording)'''
            '''[top_earlgrey_pinmux.ipconfig.hjson `enable_usb_wakeup`](hw/top_earlgrey/ip_autogen/pinmux/data/top_earlgrey_pinmux.ipconfig.hjson)'''
          ]
          kind: "spec"
          testpoint: "usb_module"
          checks: ["wake request follows events (assert_UsbModule_WakeRequestFollowsEvents)"]
          why: '''It compares `usb_wkup_req` with the three events in every cycle: 1 when at least one is 1, else 0.'''
          milestone: "V2"
          priority: "2"
          security: false
          state: "open"
        }
      ]
    }
    {
      name: '''Strap sampling'''
      conditions: [
        '''the TAP straps are seen through the TAP that connects (TAP selection and the JTAG pads); full reset and NDM reset are defined in the Terms. Life cycle conditions follow the definition table ([Manufacturing States](doc/security/specs/device_life_cycle/README.md#manufacturing-states)), after the input synchronizer delay. The pads named are Earl Grey's.'''
      ]
      requirements: [
        {
          name: REQ_STRAP_01
          desc: '''At each `strap_en_i` pulse while `dft_hold_tap_sel_i` is 0, TAP strap 0 shall take pad IOC8's value (MIO 30), in every life cycle state.'''
          source: [
            '''[Strap Sampling and TAP Isolation](hw/top_earlgrey/ip_autogen/pinmux/doc/theory_of_operation.md#strap-sampling-and-tap-isolation)'''
            '''[top_earlgrey.hjson `targets.asic.pinmux.special_signals tap0`](hw/top_earlgrey/data/top_earlgrey.hjson)'''
            '''[top_earlgrey_pinmux.ipconfig.hjson `enable_strap_sampling`](hw/top_earlgrey/ip_autogen/pinmux/data/top_earlgrey_pinmux.ipconfig.hjson)'''
          ]
          kind: "spec"
          testpoint: "strap"
          checks: ["pulse samples the straps (assert_Strap_PulseSamplesTheStraps)"]
          why: '''It compares strap 0 after a strap pulse with MIO 30 (IOC8) of the pulse cycle or the next.'''
          milestone: "V2S"
          priority: "1"
          security: true
          state: "open"
        }
        {
          name: REQ_STRAP_02a
          desc: '''At a `strap_en_i` pulse with `dft_hold_tap_sel_i` 0 and `lc_hw_debug_en_i` On, TAP strap 1 shall take pad IOC5's value (MIO 27), unless `REQ_STRAP_03` applies.'''
          source: [
            '''[Strap Sampling and TAP Isolation](hw/top_earlgrey/ip_autogen/pinmux/doc/theory_of_operation.md#strap-sampling-and-tap-isolation)'''
            '''[top_earlgrey.hjson `targets.asic.pinmux.special_signals tap1`](hw/top_earlgrey/data/top_earlgrey.hjson)'''
            '''[top_earlgrey_pinmux.ipconfig.hjson `enable_strap_sampling`](hw/top_earlgrey/ip_autogen/pinmux/data/top_earlgrey_pinmux.ipconfig.hjson)'''
            '''[Manufacturing States](doc/security/specs/device_life_cycle/README.md#manufacturing-states)'''
          ]
          kind: "spec"
          testpoint: "strap"
          checks: ["pulse samples the straps (assert_Strap_PulseSamplesTheStraps)"]
          why: '''With `lc_hw_debug_en_i` steadily On, it compares strap 1 after the pulse with MIO 27 (IOC5) of the pulse cycle or the next.'''
          milestone: "V2S"
          priority: "1"
          security: true
          state: "open"
        }
        {
          name: REQ_STRAP_02b
          desc: '''At each `strap_en_i` pulse with the live `lc_hw_debug_en_i` not On, TAP strap 1 shall keep its value, unless the sampling of `REQ_STRAP_03` applies.'''
          source: [
            '''[Strap Sampling and TAP Isolation](hw/top_earlgrey/ip_autogen/pinmux/doc/theory_of_operation.md#strap-sampling-and-tap-isolation)'''
            '''[top_earlgrey.hjson `targets.asic.pinmux.special_signals tap1`](hw/top_earlgrey/data/top_earlgrey.hjson)'''
            '''[top_earlgrey_pinmux.ipconfig.hjson `enable_strap_sampling`](hw/top_earlgrey/ip_autogen/pinmux/data/top_earlgrey_pinmux.ipconfig.hjson)'''
            '''[Manufacturing States](doc/security/specs/device_life_cycle/README.md#manufacturing-states)'''
          ]
          kind: "spec"
          testpoint: "strap"
          checks: ["pulse samples the straps (assert_Strap_PulseSamplesTheStraps)"]
          why: '''With neither `lc_hw_debug_en_i` nor `lc_dft_en_i` On before the pulse, it asserts strap 1 unchanged after it.'''
          milestone: "V2S"
          priority: "1"
          security: true
          state: "open"
        }
        {
          name: REQ_STRAP_03
          desc: '''While `lc_dft_en_i` is On and `dft_hold_tap_sel_i` is 0, both TAP straps shall take their pads' values of the cycle before.'''
          source: [
            '''[Strap Sampling and TAP Isolation](hw/top_earlgrey/ip_autogen/pinmux/doc/theory_of_operation.md#strap-sampling-and-tap-isolation)'''
            '''[top_earlgrey.hjson `targets.asic.pinmux.special_signals`](hw/top_earlgrey/data/top_earlgrey.hjson)'''
            '''[top_earlgrey_pinmux.ipconfig.hjson `enable_strap_sampling`](hw/top_earlgrey/ip_autogen/pinmux/data/top_earlgrey_pinmux.ipconfig.hjson)'''
            '''[Manufacturing States](doc/security/specs/device_life_cycle/README.md#manufacturing-states)'''
          ]
          kind: "spec"
          testpoint: "strap"
          checks: ["straps follow the pads (assert_Strap_StrapsFollowThePads)"]
          why: '''While `lc_dft_en_i` is steadily On, it compares both straps with MIO 30 and MIO 27 of the cycle before.'''
          milestone: "V2S"
          priority: "1"
          security: true
          state: "open"
        }
        {
          name: REQ_STRAP_04
          desc: '''While `dft_hold_tap_sel_i` is 1, the TAP straps shall keep their values, at a `strap_en_i` pulse too.'''
          source: [
            '''[Strap Sampling and TAP Isolation](hw/top_earlgrey/ip_autogen/pinmux/doc/theory_of_operation.md#strap-sampling-and-tap-isolation)'''
            '''[top_earlgrey_pinmux.ipconfig.hjson `enable_strap_sampling`](hw/top_earlgrey/ip_autogen/pinmux/data/top_earlgrey_pinmux.ipconfig.hjson)'''
          ]
          kind: "spec"
          testpoint: "strap"
          checks: ["straps hold (assert_Strap_StrapsHold)"]
          why: '''While `dft_hold_tap_sel_i` is 1, it asserts both straps unchanged in the next cycle, at a strap pulse and with `lc_dft_en_i` On too.'''
          milestone: "V2S"
          priority: "1"
          security: true
          state: "open"
        }
        {
          name: REQ_STRAP_05
          desc: '''Outside a `strap_en_i` pulse and the sampling of `REQ_STRAP_03` (`lc_dft_en_i` On, `dft_hold_tap_sel_i` 0), the TAP straps shall keep their values.'''
          source: [
            '''[Strap Sampling and TAP Isolation](hw/top_earlgrey/ip_autogen/pinmux/doc/theory_of_operation.md#strap-sampling-and-tap-isolation)'''
            '''[top_earlgrey_pinmux.ipconfig.hjson `enable_strap_sampling`](hw/top_earlgrey/ip_autogen/pinmux/data/top_earlgrey_pinmux.ipconfig.hjson)'''
          ]
          kind: "spec"
          testpoint: "strap"
          checks: ["straps hold (assert_Strap_StrapsHold)"]
          why: '''With no strap pulse and `lc_dft_en_i` not On in the two cycles before, it asserts both straps unchanged whatever the pads do.'''
          milestone: "V2S"
          priority: "1"
          security: true
          state: "open"
        }
        {
          name: REQ_STRAP_06
          desc: '''A TAP strap never sampled since the last full reset shall read 0.'''
          source: [
            '''[Strap Sampling and TAP Isolation](hw/top_earlgrey/ip_autogen/pinmux/doc/theory_of_operation.md#strap-sampling-and-tap-isolation)'''
            '''[top_earlgrey_pinmux.ipconfig.hjson `enable_strap_sampling`](hw/top_earlgrey/ip_autogen/pinmux/data/top_earlgrey_pinmux.ipconfig.hjson)'''
          ]
          kind: "RTL"
          testpoint: "strap"
          checks: ["unsampled strap reads 0 (assert_Strap_UnsampledStrapReads0)", "pulse samples the straps (assert_Strap_PulseSamplesTheStraps)", "straps hold (assert_Strap_StrapsHold)"]
          why: '''The first wants both straps 0 from full reset to a sample; the others keep an unsampled strap 1 at 0.'''
          milestone: "V2S"
          priority: "1"
          security: true
          state: "open"
        }
        {
          name: REQ_STRAP_07
          desc: '''An NDM reset shall leave both TAP straps unchanged.'''
          source: [
            '''[Non-debug Module Reset](hw/top_earlgrey/ip_autogen/pinmux/doc/theory_of_operation.md#non-debug-module-reset)'''
            '''[Reset Request Handling](hw/top_earlgrey/ip_autogen/pwrmgr/doc/theory_of_operation.md#reset-request-handling)'''
            '''[System Reset Tree](hw/top_earlgrey/ip_autogen/rstmgr/doc/theory_of_operation.md#system-reset-tree)'''
            '''[Summary](hw/top_earlgrey/ip_autogen/rstmgr/doc/theory_of_operation.md#summary)'''
            '''[top_earlgrey.hjson `resets.nodes lc_io_div4`](hw/top_earlgrey/data/top_earlgrey.hjson)'''
            '''[top_earlgrey.hjson `resets.nodes sys_io_div4`](hw/top_earlgrey/data/top_earlgrey.hjson)'''
            '''[top_earlgrey.hjson `module.pinmux`](hw/top_earlgrey/data/top_earlgrey.hjson)'''
            '''[top_earlgrey_pinmux.ipconfig.hjson `enable_strap_sampling`](hw/top_earlgrey/ip_autogen/pinmux/data/top_earlgrey_pinmux.ipconfig.hjson)'''
          ]
          kind: "spec"
          testpoint: "strap"
          checks: ["straps outside NDM reset (check_Strap_StrapsOutsideNdmReset)"]
          why: '''It fails on `rst_ni` or `rst_aon_ni`, which an NDM reset asserts, at a reset pin or in the input cone of a sampled TAP strap flop.'''
          milestone: "V2S"
          priority: "1"
          security: true
          state: "open"
        }
        {
          name: REQ_STRAP_08
          desc: '''With `SecVolatileRawUnlockEn` 0, the Earl Grey value, `strap_en_override_i` shall not change the straps.'''
          source: [
            '''[Inter-Module Signals](hw/top_earlgrey/ip_autogen/pinmux/doc/interfaces.md#inter-module-signals)'''
            '''[pinmux.hjson `param_list` SecVolatileRawUnlockEn](hw/top_earlgrey/ip_autogen/pinmux/data/pinmux.hjson)'''
            '''[Volatile `RAW` -> `TEST_UNLOCKED0` Transition](hw/ip/lc_ctrl/doc/programmers_guide.md#volatile-raw---test_unlocked0-transition)'''
            '''[top_earlgrey_pinmux.ipconfig.hjson `enable_strap_sampling`](hw/top_earlgrey/ip_autogen/pinmux/data/top_earlgrey_pinmux.ipconfig.hjson)'''
          ]
          kind: "spec"
          testpoint: "strap"
          checks: ["straps hold (assert_Strap_StrapsHold)"]
          why: '''With `strap_en_override_i` free in every cycle, it asserts the straps unchanged whenever no sample is due.'''
          milestone: "V2S"
          priority: "1"
          security: true
          state: "open"
        }
      ]
    }
    {
      name: '''Latched debug enable'''
      conditions: [
        '''the latch, On and Off are defined in the Terms.'''
      ]
      requirements: [
        {
          name: REQ_DBG_01a
          desc: '''At each `strap_en_i` pulse, the latch shall take On if `lc_hw_debug_en_i` is On.'''
          source: [
            '''[Non-debug Module Reset](hw/top_earlgrey/ip_autogen/pinmux/doc/theory_of_operation.md#non-debug-module-reset)'''
            '''[Inter-Module Signals](hw/top_earlgrey/ip_autogen/pinmux/doc/interfaces.md#inter-module-signals)'''
            '''[top_earlgrey_pinmux.ipconfig.hjson `enable_strap_sampling`](hw/top_earlgrey/ip_autogen/pinmux/data/top_earlgrey_pinmux.ipconfig.hjson)'''
          ]
          kind: "spec"
          testpoint: "latch"
          checks: ["pulse samples debug enable (assert_Latch_PulseSamplesDebugEnable)"]
          why: '''With `lc_hw_debug_en_i` steadily On and the clear inputs at Off, it compares `pinmux_hw_debug_en_o` with On in the next cycle.'''
          milestone: "V2S"
          priority: "1"
          security: true
          state: "open"
        }
        {
          name: REQ_DBG_01b
          desc: '''At each `strap_en_i` pulse, the latch shall take Off if `lc_hw_debug_en_i` is not On.'''
          source: [
            '''[Non-debug Module Reset](hw/top_earlgrey/ip_autogen/pinmux/doc/theory_of_operation.md#non-debug-module-reset)'''
            '''[Inter-Module Signals](hw/top_earlgrey/ip_autogen/pinmux/doc/interfaces.md#inter-module-signals)'''
            '''[top_earlgrey_pinmux.ipconfig.hjson `enable_strap_sampling`](hw/top_earlgrey/ip_autogen/pinmux/data/top_earlgrey_pinmux.ipconfig.hjson)'''
          ]
          kind: "spec"
          testpoint: "latch"
          checks: ["pulse samples debug enable (assert_Latch_PulseSamplesDebugEnable)", "On only at a pulse (assert_Latch_OnOnlyAtAPulse)"]
          why: '''The first wants Off after a pulse with the debug enable not On; the second allows a rise to On only at an On pulse.'''
          milestone: "V2S"
          priority: "1"
          security: true
          state: "open"
        }
        {
          name: REQ_DBG_02
          desc: '''With no `strap_en_i` pulse, no clear and no full reset, the latch shall keep its value, through an NDM reset too.'''
          source: [
            '''[Non-debug Module Reset](hw/top_earlgrey/ip_autogen/pinmux/doc/theory_of_operation.md#non-debug-module-reset)'''
            '''[System Reset Tree](hw/top_earlgrey/ip_autogen/rstmgr/doc/theory_of_operation.md#system-reset-tree)'''
            '''[Summary](hw/top_earlgrey/ip_autogen/rstmgr/doc/theory_of_operation.md#summary)'''
            '''[top_earlgrey.hjson `resets.nodes lc_io_div4`](hw/top_earlgrey/data/top_earlgrey.hjson)'''
            '''[top_earlgrey.hjson `resets.nodes sys_io_div4`](hw/top_earlgrey/data/top_earlgrey.hjson)'''
            '''[top_earlgrey.hjson `module.pinmux`](hw/top_earlgrey/data/top_earlgrey.hjson)'''
            '''[top_earlgrey_pinmux.ipconfig.hjson `enable_strap_sampling`](hw/top_earlgrey/ip_autogen/pinmux/data/top_earlgrey_pinmux.ipconfig.hjson)'''
          ]
          kind: "spec"
          testpoint: "latch"
          checks: ["latch holds (assert_Latch_LatchHolds)", "latch outside NDM reset (check_Latch_LatchOutsideNdmReset)"]
          why: '''The first keeps the output; the second fails on `rst_ni` or `rst_aon_ni`, NDM resets, in a latch flop's reset or input cone.'''
          milestone: "V2S"
          priority: "1"
          security: true
          state: "open"
        }
        {
          name: REQ_DBG_03
          desc: '''`lc_hw_debug_clr_i` at any value other than Off shall turn the latch Off.'''
          source: [
            '''[Non-debug Module Reset](hw/top_earlgrey/ip_autogen/pinmux/doc/theory_of_operation.md#non-debug-module-reset)'''
            '''[lc_ctrl.hjson `inter_signal_list` lc_hw_debug_clr](hw/ip/lc_ctrl/data/lc_ctrl.hjson)'''
            '''[HW_DEBUG_CLR](hw/ip/lc_ctrl/doc/theory_of_operation.md#hw_debug_clr)'''
            '''[Control Signal Propagation](hw/ip/lc_ctrl/doc/interfaces.md#control-signal-propagation)'''
            '''[top_earlgrey_pinmux.ipconfig.hjson `enable_strap_sampling`](hw/top_earlgrey/ip_autogen/pinmux/data/top_earlgrey_pinmux.ipconfig.hjson)'''
          ]
          kind: "spec"
          testpoint: "latch"
          checks: ["clear turns Off (assert_Latch_ClearTurnsOff)"]
          why: '''It wants Off in the cycle after `lc_hw_debug_clr_i` has been at any value other than Off, On included, for two cycles.'''
          milestone: "V2S"
          priority: "1"
          security: true
          state: "open"
        }
        {
          name: REQ_DBG_04
          desc: '''`lc_check_byp_en_i` at any value other than Off shall turn the latch Off.'''
          source: [
            '''[Non-debug Module Reset](hw/top_earlgrey/ip_autogen/pinmux/doc/theory_of_operation.md#non-debug-module-reset)'''
            '''[Inter-Module Signals](hw/top_earlgrey/ip_autogen/pinmux/doc/interfaces.md#inter-module-signals)'''
            '''[top_earlgrey_pinmux.ipconfig.hjson `enable_strap_sampling`](hw/top_earlgrey/ip_autogen/pinmux/data/top_earlgrey_pinmux.ipconfig.hjson)'''
          ]
          kind: "spec"
          testpoint: "latch"
          checks: ["clear turns Off (assert_Latch_ClearTurnsOff)"]
          why: '''It wants Off in the cycle after `lc_check_byp_en_i` has been at any value other than Off, On included, for two cycles.'''
          milestone: "V2S"
          priority: "1"
          security: true
          state: "open"
        }
        {
          name: REQ_DBG_05
          desc: '''`lc_escalate_en_i` at any value other than Off shall turn the latch Off.'''
          source: [
            '''[Non-debug Module Reset](hw/top_earlgrey/ip_autogen/pinmux/doc/theory_of_operation.md#non-debug-module-reset)'''
            '''[Control Signal Propagation](hw/ip/lc_ctrl/doc/interfaces.md#control-signal-propagation)'''
            '''[top_earlgrey_pinmux.ipconfig.hjson `enable_strap_sampling`](hw/top_earlgrey/ip_autogen/pinmux/data/top_earlgrey_pinmux.ipconfig.hjson)'''
          ]
          kind: "spec"
          testpoint: "latch"
          checks: ["clear turns Off (assert_Latch_ClearTurnsOff)"]
          why: '''It wants Off in the cycle after `lc_escalate_en_i` has been at any of its 15 values other than Off for two cycles.'''
          milestone: "V2S"
          priority: "1"
          security: true
          state: "open"
        }
        {
          name: REQ_DBG_06
          desc: '''`lc_hw_debug_clr_i` and `lc_check_byp_en_i` at Off shall not turn the latch Off.'''
          source: [
            '''[Non-debug Module Reset](hw/top_earlgrey/ip_autogen/pinmux/doc/theory_of_operation.md#non-debug-module-reset)'''
            '''[top_earlgrey_pinmux.ipconfig.hjson `enable_strap_sampling`](hw/top_earlgrey/ip_autogen/pinmux/data/top_earlgrey_pinmux.ipconfig.hjson)'''
          ]
          kind: "spec"
          testpoint: "latch"
          checks: ["latch holds (assert_Latch_LatchHolds)", "pulse samples debug enable (assert_Latch_PulseSamplesDebugEnable)"]
          why: '''With debug clear and check bypass Off, the first keeps the output outside a pulse and the second gives On after an On pulse.'''
          milestone: "V2S"
          priority: "1"
          security: true
          state: "open"
        }
        {
          name: REQ_DBG_07a
          desc: '''`pinmux_hw_debug_en_o` shall be On while the latch is On.'''
          source: [
            '''[Inter-Module Signals](hw/top_earlgrey/ip_autogen/pinmux/doc/interfaces.md#inter-module-signals)'''
            '''[pinmux.hjson `countermeasures` PINMUX_HW_DEBUG_EN.INTERSIG.MUBI](hw/top_earlgrey/ip_autogen/pinmux/data/pinmux.hjson)'''
            '''[top_earlgrey_pinmux.ipconfig.hjson `enable_strap_sampling`](hw/top_earlgrey/ip_autogen/pinmux/data/top_earlgrey_pinmux.ipconfig.hjson)'''
          ]
          kind: "spec"
          testpoint: "latch"
          checks: ["output On or Off (assert_Latch_OutputOnOrOff)", "pulse samples debug enable (assert_Latch_PulseSamplesDebugEnable)", "latch holds (assert_Latch_LatchHolds)"]
          why: '''The second and third want On after an On sample and while held; the first rejects other encodings.'''
          milestone: "V2S"
          priority: "1"
          security: true
          state: "open"
        }
        {
          name: REQ_DBG_07b
          desc: '''`pinmux_hw_debug_en_o` shall be Off while the latch is not On.'''
          source: [
            '''[Inter-Module Signals](hw/top_earlgrey/ip_autogen/pinmux/doc/interfaces.md#inter-module-signals)'''
            '''[pinmux.hjson `countermeasures` PINMUX_HW_DEBUG_EN.INTERSIG.MUBI](hw/top_earlgrey/ip_autogen/pinmux/data/pinmux.hjson)'''
            '''[top_earlgrey_pinmux.ipconfig.hjson `enable_strap_sampling`](hw/top_earlgrey/ip_autogen/pinmux/data/top_earlgrey_pinmux.ipconfig.hjson)'''
          ]
          kind: "spec"
          testpoint: "latch"
          checks: ["output On or Off (assert_Latch_OutputOnOrOff)", "On only at a pulse (assert_Latch_OnOnlyAtAPulse)", "clear turns Off (assert_Latch_ClearTurnsOff)"]
          why: '''The first rejects other encodings, the second an On not taken at a pulse, the third all but Off after a clear.'''
          milestone: "V2S"
          priority: "1"
          security: true
          state: "open"
        }
        {
          name: REQ_DBG_08
          desc: '''After a full reset, the latch shall be Off until the next `strap_en_i` pulse.'''
          source: [
            '''[Inter-Module Signals](hw/top_earlgrey/ip_autogen/pinmux/doc/interfaces.md#inter-module-signals)'''
            '''[lc_ctrl.hjson `inter_signal_list` lc_hw_debug_en](hw/ip/lc_ctrl/data/lc_ctrl.hjson)'''
            '''[top_earlgrey.hjson `resets.nodes lc_io_div4`](hw/top_earlgrey/data/top_earlgrey.hjson)'''
            '''[top_earlgrey.hjson `resets.nodes sys_io_div4`](hw/top_earlgrey/data/top_earlgrey.hjson)'''
            '''[top_earlgrey.hjson `module.pinmux`](hw/top_earlgrey/data/top_earlgrey.hjson)'''
            '''[top_earlgrey_pinmux.ipconfig.hjson `enable_strap_sampling`](hw/top_earlgrey/ip_autogen/pinmux/data/top_earlgrey_pinmux.ipconfig.hjson)'''
          ]
          kind: "spec"
          testpoint: "latch"
          checks: ["Off from full reset (assert_Latch_OffFromFullReset)", "On only at a pulse (assert_Latch_OnOnlyAtAPulse)"]
          why: '''The first wants Off in full reset; the second fails any rise to On before a strap pulse with the debug enable On.'''
          milestone: "V2S"
          priority: "1"
          security: true
          state: "open"
        }
        {
          name: REQ_DBG_09
          desc: '''A clear in the cycle of a `strap_en_i` pulse shall leave the latch Off.'''
          source: [
            '''[Non-debug Module Reset](hw/top_earlgrey/ip_autogen/pinmux/doc/theory_of_operation.md#non-debug-module-reset)'''
            '''[top_earlgrey_pinmux.ipconfig.hjson `enable_strap_sampling`](hw/top_earlgrey/ip_autogen/pinmux/data/top_earlgrey_pinmux.ipconfig.hjson)'''
          ]
          kind: "spec"
          testpoint: "latch"
          checks: ["clear turns Off (assert_Latch_ClearTurnsOff)"]
          why: '''With a clear input not Off for the two cycles before a pulse, the check asserts Off in the next cycle even with `lc_hw_debug_en_i` On.'''
          milestone: "V2S"
          priority: "1"
          security: true
          state: "open"
        }
      ]
    }
    {
      name: '''TAP selection and the JTAG pads'''
      conditions: [
        '''JTAG pads: IOR3 TCK, IOR0 TMS, IOR2 TDI, IOR4 TRST_N, IOR1 TDO (MIO 38, 35, 37, 39, 36; [top_earlgrey.hjson `targets.asic.pinmux.special_signals`](hw/top_earlgrey/data/top_earlgrey.hjson)). Rows hold once straps and life cycle inputs have held for the delay of the input synchronizers, except TRST_N in scan mode.'''
        '''REQ_TAP_08 takes "all-zero" ([Strap Sampling and TAP Isolation](hw/top_earlgrey/ip_autogen/pinmux/doc/theory_of_operation.md#strap-sampling-and-tap-isolation)); the existing testplan's `MioJtagAttrO_A` keeps the Schmitt trigger on.'''
      ]
      requirements: [
        {
          name: REQ_TAP_01a
          desc: '''With TAP straps 01, `lc_jtag_o` shall carry TCK from its pad, in every life cycle state.'''
          source: [
            '''[Strap Sampling and TAP Isolation](hw/top_earlgrey/ip_autogen/pinmux/doc/theory_of_operation.md#strap-sampling-and-tap-isolation)'''
            '''[top_earlgrey.hjson `inter_module.connect pinmux.lc_jtag`](hw/top_earlgrey/data/top_earlgrey.hjson)'''
            '''[top_earlgrey.hjson `targets.asic.pinmux.special_signals`](hw/top_earlgrey/data/top_earlgrey.hjson)'''
            '''[top_earlgrey_pinmux.ipconfig.hjson `enable_strap_sampling`](hw/top_earlgrey/ip_autogen/pinmux/data/top_earlgrey_pinmux.ipconfig.hjson)'''
          ]
          kind: "spec"
          testpoint: "jtag"
          checks: ["connected TAP gets the pads (assert_Jtag_ConnectedTapGetsThePads)"]
          why: '''It compares `tck` of `lc_jtag_o` with MIO 38 (IOR3) in the same cycle, in every life cycle state and in scan mode.'''
          milestone: "V2S"
          priority: "1"
          security: true
          state: "open"
        }
        {
          name: REQ_TAP_01b
          desc: '''With TAP straps 01, `lc_jtag_o` shall carry TMS from its pad, in every life cycle state.'''
          source: [
            '''[Strap Sampling and TAP Isolation](hw/top_earlgrey/ip_autogen/pinmux/doc/theory_of_operation.md#strap-sampling-and-tap-isolation)'''
            '''[top_earlgrey.hjson `inter_module.connect pinmux.lc_jtag`](hw/top_earlgrey/data/top_earlgrey.hjson)'''
            '''[top_earlgrey.hjson `targets.asic.pinmux.special_signals`](hw/top_earlgrey/data/top_earlgrey.hjson)'''
            '''[top_earlgrey_pinmux.ipconfig.hjson `enable_strap_sampling`](hw/top_earlgrey/ip_autogen/pinmux/data/top_earlgrey_pinmux.ipconfig.hjson)'''
          ]
          kind: "spec"
          testpoint: "jtag"
          checks: ["connected TAP gets the pads (assert_Jtag_ConnectedTapGetsThePads)"]
          why: '''It compares `tms` of `lc_jtag_o` with MIO 35 (IOR0) in the same cycle, in every life cycle state and in scan mode.'''
          milestone: "V2S"
          priority: "1"
          security: true
          state: "open"
        }
        {
          name: REQ_TAP_01c
          desc: '''With TAP straps 01, `lc_jtag_o` shall carry TDI from its pad, in every life cycle state.'''
          source: [
            '''[Strap Sampling and TAP Isolation](hw/top_earlgrey/ip_autogen/pinmux/doc/theory_of_operation.md#strap-sampling-and-tap-isolation)'''
            '''[top_earlgrey.hjson `inter_module.connect pinmux.lc_jtag`](hw/top_earlgrey/data/top_earlgrey.hjson)'''
            '''[top_earlgrey.hjson `targets.asic.pinmux.special_signals`](hw/top_earlgrey/data/top_earlgrey.hjson)'''
            '''[top_earlgrey_pinmux.ipconfig.hjson `enable_strap_sampling`](hw/top_earlgrey/ip_autogen/pinmux/data/top_earlgrey_pinmux.ipconfig.hjson)'''
          ]
          kind: "spec"
          testpoint: "jtag"
          checks: ["connected TAP gets the pads (assert_Jtag_ConnectedTapGetsThePads)"]
          why: '''It compares `tdi` of `lc_jtag_o` with MIO 37 (IOR2) in the same cycle, in every life cycle state and in scan mode.'''
          milestone: "V2S"
          priority: "1"
          security: true
          state: "open"
        }
        {
          name: REQ_TAP_01d
          desc: '''With TAP straps 01, `lc_jtag_o` shall carry TRST_N from its pad, in every life cycle state.'''
          source: [
            '''[Strap Sampling and TAP Isolation](hw/top_earlgrey/ip_autogen/pinmux/doc/theory_of_operation.md#strap-sampling-and-tap-isolation)'''
            '''[top_earlgrey.hjson `inter_module.connect pinmux.lc_jtag`](hw/top_earlgrey/data/top_earlgrey.hjson)'''
            '''[top_earlgrey.hjson `targets.asic.pinmux.special_signals`](hw/top_earlgrey/data/top_earlgrey.hjson)'''
            '''[top_earlgrey_pinmux.ipconfig.hjson `enable_strap_sampling`](hw/top_earlgrey/ip_autogen/pinmux/data/top_earlgrey_pinmux.ipconfig.hjson)'''
          ]
          kind: "spec"
          testpoint: "jtag"
          checks: ["connected TAP gets the pads (assert_Jtag_ConnectedTapGetsThePads)"]
          why: '''Outside scan mode it compares `trst_n` with MIO 39 (IOR4) in the same cycle; in scan mode no specification names its reset.'''
          milestone: "V2S"
          priority: "1"
          security: true
          state: "open"
        }
        {
          name: REQ_TAP_02a
          desc: '''With TAP straps 10, `rv_jtag_o` shall carry the four input pads while the latch is On.'''
          source: [
            '''[Strap Sampling and TAP Isolation](hw/top_earlgrey/ip_autogen/pinmux/doc/theory_of_operation.md#strap-sampling-and-tap-isolation)'''
            '''[Non-debug Module Reset](hw/top_earlgrey/ip_autogen/pinmux/doc/theory_of_operation.md#non-debug-module-reset)'''
            '''[Inter-Module Signals](hw/top_earlgrey/ip_autogen/pinmux/doc/interfaces.md#inter-module-signals)'''
            '''[top_earlgrey.hjson `inter_module.connect pinmux.rv_jtag`](hw/top_earlgrey/data/top_earlgrey.hjson)'''
            '''[top_earlgrey.hjson `targets.asic.pinmux.special_signals`](hw/top_earlgrey/data/top_earlgrey.hjson)'''
            '''[top_earlgrey_pinmux.ipconfig.hjson `enable_strap_sampling`](hw/top_earlgrey/ip_autogen/pinmux/data/top_earlgrey_pinmux.ipconfig.hjson)'''
          ]
          kind: "spec"
          testpoint: "jtag"
          checks: ["connected TAP gets the pads (assert_Jtag_ConnectedTapGetsThePads)"]
          why: '''It compares `rv_jtag_o` with the JTAG pads in the same cycle, TRST_N outside scan mode only.'''
          milestone: "V2S"
          priority: "1"
          security: true
          state: "open"
        }
        {
          name: REQ_TAP_02b
          desc: '''With TAP straps 10, `rv_jtag_o` shall not carry the four input pads while the latch is Off.'''
          source: [
            '''[Strap Sampling and TAP Isolation](hw/top_earlgrey/ip_autogen/pinmux/doc/theory_of_operation.md#strap-sampling-and-tap-isolation)'''
            '''[Non-debug Module Reset](hw/top_earlgrey/ip_autogen/pinmux/doc/theory_of_operation.md#non-debug-module-reset)'''
            '''[Inter-Module Signals](hw/top_earlgrey/ip_autogen/pinmux/doc/interfaces.md#inter-module-signals)'''
            '''[top_earlgrey.hjson `inter_module.connect pinmux.rv_jtag`](hw/top_earlgrey/data/top_earlgrey.hjson)'''
            '''[top_earlgrey.hjson `targets.asic.pinmux.special_signals`](hw/top_earlgrey/data/top_earlgrey.hjson)'''
            '''[top_earlgrey_pinmux.ipconfig.hjson `enable_strap_sampling`](hw/top_earlgrey/ip_autogen/pinmux/data/top_earlgrey_pinmux.ipconfig.hjson)'''
          ]
          kind: "spec"
          testpoint: "jtag"
          checks: ["cut TAP gets zero (assert_Jtag_CutTapGetsZero)"]
          why: '''With TAP straps 10 and `pinmux_hw_debug_en_o` Off, it asserts all four fields of `rv_jtag_o` 0.'''
          milestone: "V2S"
          priority: "1"
          security: true
          state: "open"
        }
        {
          name: REQ_TAP_03a
          desc: '''With TAP straps 11, `dft_jtag_o` shall carry the four input pads while `lc_dft_en_i` is On.'''
          source: [
            '''[Strap Sampling and TAP Isolation](hw/top_earlgrey/ip_autogen/pinmux/doc/theory_of_operation.md#strap-sampling-and-tap-isolation)'''
            '''[pinmux.hjson `countermeasures` TAP.MUX.LC_GATED](hw/top_earlgrey/ip_autogen/pinmux/data/pinmux.hjson)'''
            '''[top_earlgrey.hjson `inter_module.top`](hw/top_earlgrey/data/top_earlgrey.hjson)'''
            '''[top_earlgrey.hjson `targets.asic.pinmux.special_signals`](hw/top_earlgrey/data/top_earlgrey.hjson)'''
            '''[top_earlgrey_pinmux.ipconfig.hjson `enable_strap_sampling`](hw/top_earlgrey/ip_autogen/pinmux/data/top_earlgrey_pinmux.ipconfig.hjson)'''
          ]
          kind: "spec"
          testpoint: "jtag"
          checks: ["connected TAP gets the pads (assert_Jtag_ConnectedTapGetsThePads)"]
          why: '''With `lc_dft_en_i` steadily On, it compares `dft_jtag_o` with the JTAG pads in the same cycle, TRST_N outside scan mode only.'''
          milestone: "V2S"
          priority: "1"
          security: true
          state: "open"
        }
        {
          name: REQ_TAP_03b
          desc: '''With TAP straps 11, `dft_jtag_o` shall not carry the four input pads while `lc_dft_en_i` is Off.'''
          source: [
            '''[Strap Sampling and TAP Isolation](hw/top_earlgrey/ip_autogen/pinmux/doc/theory_of_operation.md#strap-sampling-and-tap-isolation)'''
            '''[pinmux.hjson `countermeasures` TAP.MUX.LC_GATED](hw/top_earlgrey/ip_autogen/pinmux/data/pinmux.hjson)'''
            '''[top_earlgrey.hjson `inter_module.top`](hw/top_earlgrey/data/top_earlgrey.hjson)'''
            '''[top_earlgrey.hjson `targets.asic.pinmux.special_signals`](hw/top_earlgrey/data/top_earlgrey.hjson)'''
            '''[top_earlgrey_pinmux.ipconfig.hjson `enable_strap_sampling`](hw/top_earlgrey/ip_autogen/pinmux/data/top_earlgrey_pinmux.ipconfig.hjson)'''
          ]
          kind: "spec"
          testpoint: "jtag"
          checks: ["cut TAP gets zero (assert_Jtag_CutTapGetsZero)"]
          why: '''With TAP straps 11 and `lc_dft_en_i` not On in the two cycles before, it asserts `dft_jtag_o` all 0.'''
          milestone: "V2S"
          priority: "1"
          security: true
          state: "open"
        }
        {
          name: REQ_TAP_04
          desc: '''Each of the life cycle, RISC-V and DFT TAPs shall receive an all-zero request while it is not connected.'''
          source: [
            '''[Strap Sampling and TAP Isolation](hw/top_earlgrey/ip_autogen/pinmux/doc/theory_of_operation.md#strap-sampling-and-tap-isolation)'''
            '''[top_earlgrey.hjson `inter_module.connect`](hw/top_earlgrey/data/top_earlgrey.hjson)'''
            '''[top_earlgrey.hjson `inter_module.top`](hw/top_earlgrey/data/top_earlgrey.hjson)'''
            '''[top_earlgrey_pinmux.ipconfig.hjson `enable_strap_sampling`](hw/top_earlgrey/ip_autogen/pinmux/data/top_earlgrey_pinmux.ipconfig.hjson)'''
          ]
          kind: "spec"
          testpoint: "jtag"
          checks: ["cut TAP gets zero (assert_Jtag_CutTapGetsZero)"]
          why: '''In every cycle and scan mode value, each cut one of the life cycle, RISC-V and DFT TAPs must see all four fields 0.'''
          milestone: "V2S"
          priority: "1"
          security: true
          state: "open"
        }
        {
          name: REQ_TAP_05
          desc: '''`lc_dft_en_i` and `lc_hw_debug_en_i` shall count as On only at 4'b0101, in strap sampling, the latch and TAP selection.'''
          source: [
            '''[Control Signal Propagation](hw/ip/lc_ctrl/doc/interfaces.md#control-signal-propagation)'''
            '''[pinmux.hjson `countermeasures` LC_DFT_EN.INTERSIG.MUBI](hw/top_earlgrey/ip_autogen/pinmux/data/pinmux.hjson)'''
            '''[top_earlgrey_pinmux.ipconfig.hjson `enable_strap_sampling`](hw/top_earlgrey/ip_autogen/pinmux/data/top_earlgrey_pinmux.ipconfig.hjson)'''
          ]
          kind: "spec"
          testpoint: "jtag"
          checks: ["only On opens", "cut TAP gets zero (assert_Jtag_CutTapGetsZero)", "pulse samples the straps (assert_Strap_PulseSamplesTheStraps)", "straps hold (assert_Strap_StrapsHold)", "pulse samples debug enable (assert_Latch_PulseSamplesDebugEnable)"]
          why: '''Each counts only 4'b0101 as On.'''
          milestone: "V2S"
          priority: "1"
          security: true
          state: "open"
        }
        {
          name: REQ_TAP_06a
          desc: '''While a TAP is connected, pad IOR1 shall drive the TAP's TDO.'''
          source: [
            '''[top_earlgrey.hjson `targets.asic.pinmux.special_signals tdo`](hw/top_earlgrey/data/top_earlgrey.hjson)'''
            '''[JTAG](hw/ip/rv_dm/doc/interfaces.md#jtag)'''
            '''[Security Countermeasures](hw/ip/lc_ctrl/doc/interfaces.md#security-countermeasures)'''
            '''[top_earlgrey_pinmux.ipconfig.hjson `enable_strap_sampling`](hw/top_earlgrey/ip_autogen/pinmux/data/top_earlgrey_pinmux.ipconfig.hjson)'''
          ]
          kind: "spec"
          testpoint: "jtag_pad"
          checks: ["TDO pad drives the TAP (assert_JtagPad_TdoPadDrivesTheTap)"]
          why: '''It compares `mio_out_o[36]` with the connected TAP's `tdo`, the RRAM TAP's included, in the same cycle while the pad is awake.'''
          milestone: "V2S"
          priority: "2"
          security: true
          state: "open"
        }
        {
          name: REQ_TAP_06b
          desc: '''While a TAP is connected, pad IOR1 shall drive the TAP's output enable.'''
          source: [
            '''[top_earlgrey.hjson `targets.asic.pinmux.special_signals tdo`](hw/top_earlgrey/data/top_earlgrey.hjson)'''
            '''[JTAG](hw/ip/rv_dm/doc/interfaces.md#jtag)'''
            '''[Security Countermeasures](hw/ip/lc_ctrl/doc/interfaces.md#security-countermeasures)'''
            '''[top_earlgrey_pinmux.ipconfig.hjson `enable_strap_sampling`](hw/top_earlgrey/ip_autogen/pinmux/data/top_earlgrey_pinmux.ipconfig.hjson)'''
          ]
          kind: "spec"
          testpoint: "jtag_pad"
          checks: ["TDO pad drives the TAP (assert_JtagPad_TdoPadDrivesTheTap)"]
          why: '''It compares `mio_oe_o[36]` with the connected TAP's `tdo_oe` in the same cycle while the pad is awake.'''
          milestone: "V2S"
          priority: "2"
          security: true
          state: "open"
        }
        {
          name: REQ_TAP_07
          desc: '''While a TAP is connected, pads IOR0, IOR2, IOR3 and IOR4 shall have output enable 0.'''
          source: [
            '''The TAPs' standard JTAG port takes TCK, TMS, TRST_N and TDI as pad inputs and drives only TDO and its enable ([JTAG](hw/ip/rv_dm/doc/interfaces.md#jtag); [Security Countermeasures](hw/ip/lc_ctrl/doc/interfaces.md#security-countermeasures)); the RRAM TAP's port has the same JTAG type ([Inter-Module Signals](hw/top_earlgrey/ip_autogen/pinmux/doc/interfaces.md#inter-module-signals)) and takes the JTAG IOs ([Strap Sampling and TAP Isolation](hw/top_earlgrey/ip_autogen/pinmux/doc/theory_of_operation.md#strap-sampling-and-tap-isolation))'''
            '''[top_earlgrey.hjson `targets.asic.pinmux.special_signals`](hw/top_earlgrey/data/top_earlgrey.hjson)'''
            '''[top_earlgrey_pinmux.ipconfig.hjson `enable_strap_sampling`](hw/top_earlgrey/ip_autogen/pinmux/data/top_earlgrey_pinmux.ipconfig.hjson)'''
          ]
          kind: "spec"
          testpoint: "jtag_pad"
          checks: ["input pads not driven (assert_JtagPad_InputPadsNotDriven)"]
          why: '''While a TAP is connected and the pads awake, it asserts `mio_oe_o` 0 on MIO 35, 37, 38 and 39 whatever their output selects hold.'''
          milestone: "V2S"
          priority: "2"
          security: true
          state: "open"
        }
        {
          name: REQ_TAP_08
          desc: '''While a TAP is connected, every attribute of the five JTAG pads shall be 0.'''
          source: [
            '''[Strap Sampling and TAP Isolation](hw/top_earlgrey/ip_autogen/pinmux/doc/theory_of_operation.md#strap-sampling-and-tap-isolation)'''
            '''[top_earlgrey.hjson `targets.asic.pinmux.special_signals`](hw/top_earlgrey/data/top_earlgrey.hjson)'''
            '''[top_earlgrey_pinmux.ipconfig.hjson `enable_strap_sampling`](hw/top_earlgrey/ip_autogen/pinmux/data/top_earlgrey_pinmux.ipconfig.hjson)'''
          ]
          kind: "spec"
          testpoint: "jtag_pad"
          checks: ["JTAG attributes zero (assert_JtagPad_JtagAttributesZero)"]
          why: '''While a TAP is connected and the pads awake, it asserts every field of `mio_attr_o` 0 on MIO 35 to 39, whatever the registers hold.'''
          milestone: "V2S"
          priority: "2"
          security: true
          state: "open"
        }
        {
          name: REQ_TAP_09
          desc: '''Connecting a TAP shall not change the JTAG pads' attribute registers.'''
          source: [
            '''[Strap Sampling and TAP Isolation](hw/top_earlgrey/ip_autogen/pinmux/doc/theory_of_operation.md#strap-sampling-and-tap-isolation)'''
            '''[top_earlgrey.hjson `targets.asic.pinmux.special_signals`](hw/top_earlgrey/data/top_earlgrey.hjson)'''
            '''[top_earlgrey_pinmux.ipconfig.hjson `enable_strap_sampling`](hw/top_earlgrey/ip_autogen/pinmux/data/top_earlgrey_pinmux.ipconfig.hjson)'''
          ]
          kind: "spec"
          testpoint: "jtag_pad"
          checks: ["attribute registers untouched (assert_JtagPad_AttributeRegistersUntouched)"]
          why: '''In every cycle it lets each JTAG pad's attribute read-back change only by a software write.'''
          milestone: "V2S"
          priority: "2"
          security: true
          state: "open"
        }
        {
          name: REQ_TAP_12
          desc: '''An NDM reset with no clear shall leave a connected RISC-V TAP connected.'''
          source: [
            '''[Life Cycle Control](hw/ip/rv_dm/doc/interfaces.md#life-cycle-control)'''
            '''[Non-debug Module Reset](hw/top_earlgrey/ip_autogen/pinmux/doc/theory_of_operation.md#non-debug-module-reset)'''
            '''[lc_ctrl.hjson `inter_signal_list` lc_hw_debug_en](hw/ip/lc_ctrl/data/lc_ctrl.hjson)'''
            '''[top_earlgrey.hjson `resets.nodes lc_io_div4`](hw/top_earlgrey/data/top_earlgrey.hjson)'''
            '''[top_earlgrey.hjson `resets.nodes sys_io_div4`](hw/top_earlgrey/data/top_earlgrey.hjson)'''
            '''[top_earlgrey.hjson `module.pinmux`](hw/top_earlgrey/data/top_earlgrey.hjson)'''
            '''[top_earlgrey.hjson `inter_module.connect pinmux.rv_jtag`](hw/top_earlgrey/data/top_earlgrey.hjson)'''
            '''[top_earlgrey_pinmux.ipconfig.hjson `enable_strap_sampling`](hw/top_earlgrey/ip_autogen/pinmux/data/top_earlgrey_pinmux.ipconfig.hjson)'''
            '''[System Reset Tree](hw/top_earlgrey/ip_autogen/rstmgr/doc/theory_of_operation.md#system-reset-tree)'''
            '''[Summary](hw/top_earlgrey/ip_autogen/rstmgr/doc/theory_of_operation.md#summary)'''
          ]
          kind: "spec"
          testpoint: "jtag"
          checks: ["TAP selection outside NDM reset (check_Jtag_TapSelectionOutsideNdmReset)", "connected TAP gets the pads (assert_Jtag_ConnectedTapGetsThePads)", "cut TAP gets zero (assert_Jtag_CutTapGetsZero)"]
          why: '''An NDM reset reaches no TAP selection flop, and that state alone picks the TAP.'''
          milestone: "V2S"
          priority: "1"
          security: true
          state: "open"
        }
      ]
    }
    {
      name: '''RRAM TAP'''
      conditions: [
        '''a top with the RRAM TAP ([top_earlgrey_pinmux.ipconfig.hjson](hw/top_earlgrey/ip_autogen/pinmux/data/top_earlgrey_pinmux.ipconfig.hjson) `enable_rram_tap`) has these rows. On another top, TAP straps 00 select no TAP ([Strap Sampling and TAP Isolation](hw/top_earlgrey/ip_autogen/pinmux/doc/theory_of_operation.md#strap-sampling-and-tap-isolation)). The JTAG pad rows of TAP selection and the JTAG pads hold for it too, as a connected TAP, and its TRST_N in scan mode has no row. The rows hold once the straps and `lc_nvm_debug_en_i` have held for the delay of the input synchronizers. The TCK and TRST_N of `REQ_RRAM_01` follow their pads from a connection's second `clk_i` cycle.'''
      ]
      requirements: [
        {
          name: REQ_RRAM_01
          desc: '''With TAP straps 00, `rram_jtag_o` shall carry the four input pads while `RRAM_JTAG_SEL` is `kMultiBitBool4True` and `lc_nvm_debug_en_i` is On.'''
          source: [
            '''[Strap Sampling and TAP Isolation](hw/top_earlgrey/ip_autogen/pinmux/doc/theory_of_operation.md#strap-sampling-and-tap-isolation)'''
            '''[Inter-Module Signals](hw/top_earlgrey/ip_autogen/pinmux/doc/interfaces.md#inter-module-signals)'''
            '''[pinmux.hjson `countermeasures` TAP.MUX.LC_GATED](hw/top_earlgrey/ip_autogen/pinmux/data/pinmux.hjson)'''
            '''!!RRAM_JTAG_SEL'''
            '''[top_earlgrey.hjson `inter_module.connect pinmux.rram_jtag`](hw/top_earlgrey/data/top_earlgrey.hjson)'''
            '''[top_earlgrey.hjson `targets.asic.pinmux.special_signals`](hw/top_earlgrey/data/top_earlgrey.hjson)'''
            '''[top_earlgrey_pinmux.ipconfig.hjson `enable_rram_tap`](hw/top_earlgrey/ip_autogen/pinmux/data/top_earlgrey_pinmux.ipconfig.hjson)'''
          ]
          kind: "spec"
          testpoint: "rram_tap"
          checks: ["connected RRAM TAP gets the pads (assert_RramTap_ConnectedRramTapGetsThePads)"]
          why: '''While connected, it compares `rram_jtag_o` with MIO 38, 35, 37 and 39 in the same cycle, `tck` and `trst_n` from its second cycle.'''
          milestone: "V2S"
          priority: "2"
          security: true
          state: "open"
        }
        {
          name: REQ_RRAM_02
          desc: '''While the RRAM TAP is not connected, `rram_jtag_o` shall carry TMS 0 and TDI 0.'''
          source: [
            '''[Strap Sampling and TAP Isolation](hw/top_earlgrey/ip_autogen/pinmux/doc/theory_of_operation.md#strap-sampling-and-tap-isolation)'''
            '''!!RRAM_JTAG_SEL'''
            '''[Inter-Module Signals](hw/top_earlgrey/ip_autogen/pinmux/doc/interfaces.md#inter-module-signals)'''
            '''[top_earlgrey_pinmux.ipconfig.hjson `enable_rram_tap`](hw/top_earlgrey/ip_autogen/pinmux/data/top_earlgrey_pinmux.ipconfig.hjson)'''
          ]
          kind: "spec"
          testpoint: "rram_tap"
          checks: ["cut RRAM TAP gets TMS and TDI 0 (assert_RramTap_CutRramTapGetsTmsAndTdi0)"]
          why: '''In every cut cycle from the release of `rst_ni` on, it asserts `tms` and `tdi` 0 whatever the pads carry.'''
          milestone: "V2S"
          priority: "2"
          security: true
          state: "open"
        }
        {
          name: REQ_RRAM_03
          desc: '''The TCK and TRST_N of `rram_jtag_o` shall be 0 in reset and in the `clk_i` cycle after reset or after any cycle with the RRAM TAP not connected.'''
          source: [
            '''[Strap Sampling and TAP Isolation](hw/top_earlgrey/ip_autogen/pinmux/doc/theory_of_operation.md#strap-sampling-and-tap-isolation)'''
            '''[pinmux.hjson `clocking`](hw/top_earlgrey/ip_autogen/pinmux/data/pinmux.hjson)'''
            '''[top_earlgrey_pinmux.ipconfig.hjson `enable_rram_tap`](hw/top_earlgrey/ip_autogen/pinmux/data/top_earlgrey_pinmux.ipconfig.hjson)'''
          ]
          kind: "RTL"
          testpoint: "rram_tap"
          checks: ["TCK and TRST low after a cut (assert_RramTap_TckAndTrstLowAfterACut)"]
          why: '''It asserts `tck` and `trst_n` of `rram_jtag_o` 0 in reset, in the first cycle after it and in every cycle after a cut one.'''
          milestone: "V2S"
          priority: "2"
          security: true
          state: "open"
        }
        {
          name: REQ_RRAM_09
          desc: '''Outside reset, in the first `clk_i` cycle with the RRAM TAP no longer connected, the TCK and TRST_N of `rram_jtag_o` shall still carry their pads' values.'''
          source: [
            '''[Strap Sampling and TAP Isolation](hw/top_earlgrey/ip_autogen/pinmux/doc/theory_of_operation.md#strap-sampling-and-tap-isolation)'''
            '''[pinmux.hjson `clocking`](hw/top_earlgrey/ip_autogen/pinmux/data/pinmux.hjson)'''
            '''[top_earlgrey_pinmux.ipconfig.hjson `enable_rram_tap`](hw/top_earlgrey/ip_autogen/pinmux/data/top_earlgrey_pinmux.ipconfig.hjson)'''
          ]
          kind: "spec"
          testpoint: "rram_tap"
          checks: ["TCK and TRST run one cycle more (assert_RramTap_TckAndTrstRunOneCycleMore)"]
          why: '''In the first cut cycle after a connected one, outside reset, it compares `tck` and `trst_n` with MIO 38 and 39.'''
          milestone: "V2S"
          priority: "2"
          security: true
          state: "open"
        }
        {
          name: REQ_RRAM_04
          desc: '''`lc_nvm_debug_en_i` shall count as On only at 4'b0101 in the RRAM TAP's selection.'''
          source: [
            '''[Control Signal Propagation](hw/ip/lc_ctrl/doc/interfaces.md#control-signal-propagation)'''
            '''[pinmux.hjson `countermeasures` LC_NVM_DEBUG_EN.INTERSIG.MUBI](hw/top_earlgrey/ip_autogen/pinmux/data/pinmux.hjson)'''
            '''[top_earlgrey_pinmux.ipconfig.hjson `enable_rram_tap`](hw/top_earlgrey/ip_autogen/pinmux/data/top_earlgrey_pinmux.ipconfig.hjson)'''
          ]
          kind: "spec"
          testpoint: "rram_tap"
          checks: ["only True and On open", "cut RRAM TAP gets TMS and TDI 0 (assert_RramTap_CutRramTapGetsTmsAndTdi0)"]
          why: '''With `lc_nvm_debug_en_i` free, any held value but 4'b0101 cuts the TAP and the second wants TMS and TDI 0.'''
          milestone: "V2S"
          priority: "2"
          security: true
          state: "open"
        }
        {
          name: REQ_RRAM_05
          desc: '''After a reset, the RRAM TAP shall not be connected until software writes `kMultiBitBool4True` to `RRAM_JTAG_SEL`.'''
          source: [
            '''[Strap Sampling and TAP Isolation](hw/top_earlgrey/ip_autogen/pinmux/doc/theory_of_operation.md#strap-sampling-and-tap-isolation)'''
            '''!!RRAM_JTAG_SEL'''
            '''[top_earlgrey_pinmux.ipconfig.hjson `enable_rram_tap`](hw/top_earlgrey/ip_autogen/pinmux/data/top_earlgrey_pinmux.ipconfig.hjson)'''
          ]
          kind: "spec"
          testpoint: "rram_tap"
          checks: ["cut until the register is written (assert_RramTap_CutUntilTheRegisterIsWritten)"]
          why: '''Until the first accepted write to `RRAM_JTAG_SEL`, it asserts `tms` and `tdi` 0 whatever the straps and `lc_nvm_debug_en_i`.'''
          milestone: "V2S"
          priority: "2"
          security: true
          state: "open"
        }
        {
          name: REQ_RRAM_06
          desc: '''`RRAM_JTAG_SEL` and `lc_nvm_debug_en_i` shall not change which of the life cycle, RISC-V and DFT TAPs is connected, nor what it receives.'''
          source: [
            '''[Strap Sampling and TAP Isolation](hw/top_earlgrey/ip_autogen/pinmux/doc/theory_of_operation.md#strap-sampling-and-tap-isolation)'''
            '''!!RRAM_JTAG_SEL'''
            '''[top_earlgrey_pinmux.ipconfig.hjson `enable_rram_tap`](hw/top_earlgrey/ip_autogen/pinmux/data/top_earlgrey_pinmux.ipconfig.hjson)'''
          ]
          kind: "spec"
          testpoint: "rram_tap"
          checks: ["connected TAP gets the pads (assert_Jtag_ConnectedTapGetsThePads)", "cut TAP gets zero (assert_Jtag_CutTapGetsZero)"]
          why: '''Both decide the life cycle, RISC-V and DFT TAPs with `RRAM_JTAG_SEL` and `lc_nvm_debug_en_i` free.'''
          milestone: "V2S"
          priority: "2"
          security: true
          state: "open"
        }
        {
          name: REQ_RRAM_07
          desc: '''`lc_check_byp_en_i` and the latch shall not change whether the RRAM TAP is connected.'''
          source: [
            '''[Strap Sampling and TAP Isolation](hw/top_earlgrey/ip_autogen/pinmux/doc/theory_of_operation.md#strap-sampling-and-tap-isolation)'''
            '''[Non-debug Module Reset](hw/top_earlgrey/ip_autogen/pinmux/doc/theory_of_operation.md#non-debug-module-reset)'''
            '''[top_earlgrey_pinmux.ipconfig.hjson `enable_rram_tap`](hw/top_earlgrey/ip_autogen/pinmux/data/top_earlgrey_pinmux.ipconfig.hjson)'''
          ]
          kind: "spec"
          testpoint: "rram_tap"
          checks: ["RRAM TAP kept through a transition (assert_RramTap_RramTapKeptThroughATransition)", "cut RRAM TAP gets TMS and TDI 0 (assert_RramTap_CutRramTapGetsTmsAndTdi0)"]
          why: '''The first keeps a connected TAP connected in a transition or with the latch Off.'''
          milestone: "V2S"
          priority: "2"
          security: true
          state: "open"
        }
      ]
    }
    {
      name: '''DFT straps'''
      conditions: [
        '''`dft_strap_test_o` holds a valid bit and the straps. The straps take bit 0 from IOR5 (MIO 40) and bit 1 from IOR7 (MIO 42) ([existing pinmux FPV testplan: DftStrapTestO_A](hw/top_earlgrey/ip_autogen/pinmux/data/pinmux_fpv_testplan.hjson)).'''
        '''The top description gives two DFT strap pads, the theory of operation three ([Strap Sampling and TAP Isolation](hw/top_earlgrey/ip_autogen/pinmux/doc/theory_of_operation.md#strap-sampling-and-tap-isolation)); the rows follow the top.'''
      ]
      requirements: [
        {
          name: REQ_DFT_01a
          desc: '''At a `strap_en_i` pulse with `lc_dft_en_i` On, `dft_strap_test_o` shall take valid 1.'''
          source: [
            '''[Strap Sampling and TAP Isolation](hw/top_earlgrey/ip_autogen/pinmux/doc/theory_of_operation.md#strap-sampling-and-tap-isolation)'''
            '''[Inter-Module Signals](hw/top_earlgrey/ip_autogen/pinmux/doc/interfaces.md#inter-module-signals)'''
            '''[top_earlgrey.hjson `targets.asic.pinmux.special_signals`](hw/top_earlgrey/data/top_earlgrey.hjson)'''
            '''[top_earlgrey_pinmux.ipconfig.hjson `enable_strap_sampling`](hw/top_earlgrey/ip_autogen/pinmux/data/top_earlgrey_pinmux.ipconfig.hjson)'''
            '''[Manufacturing States](doc/security/specs/device_life_cycle/README.md#manufacturing-states)'''
          ]
          kind: "spec"
          testpoint: "dft_strap"
          checks: ["pulse samples DFT straps (assert_DftStrap_PulseSamplesDftStraps)"]
          why: '''At a strap pulse with `lc_dft_en_i` On for the two cycles before, it asserts the valid bit 1 from the next cycle.'''
          milestone: "V2S"
          priority: "2"
          security: true
          state: "open"
        }
        {
          name: REQ_DFT_01b
          desc: '''At a `strap_en_i` pulse with `lc_dft_en_i` On, the straps of `dft_strap_test_o` shall take the DFT strap pads' values.'''
          source: [
            '''[Strap Sampling and TAP Isolation](hw/top_earlgrey/ip_autogen/pinmux/doc/theory_of_operation.md#strap-sampling-and-tap-isolation)'''
            '''[Inter-Module Signals](hw/top_earlgrey/ip_autogen/pinmux/doc/interfaces.md#inter-module-signals)'''
            '''[top_earlgrey.hjson `targets.asic.pinmux.special_signals`](hw/top_earlgrey/data/top_earlgrey.hjson)'''
            '''[top_earlgrey_pinmux.ipconfig.hjson `enable_strap_sampling`](hw/top_earlgrey/ip_autogen/pinmux/data/top_earlgrey_pinmux.ipconfig.hjson)'''
            '''[Manufacturing States](doc/security/specs/device_life_cycle/README.md#manufacturing-states)'''
          ]
          kind: "spec"
          testpoint: "dft_strap"
          checks: ["pulse samples DFT straps (assert_DftStrap_PulseSamplesDftStraps)"]
          why: '''With `lc_dft_en_i` steadily On, it compares the straps after the pulse with MIO 40 and MIO 42 of the pulse cycle or the next.'''
          milestone: "V2S"
          priority: "2"
          security: true
          state: "open"
        }
        {
          name: REQ_DFT_02a
          desc: '''Once valid, `dft_strap_test_o` shall keep valid 1 until a full reset.'''
          source: [
            '''[Strap Sampling and TAP Isolation](hw/top_earlgrey/ip_autogen/pinmux/doc/theory_of_operation.md#strap-sampling-and-tap-isolation)'''
            '''[Non-debug Module Reset](hw/top_earlgrey/ip_autogen/pinmux/doc/theory_of_operation.md#non-debug-module-reset)'''
            '''[top_earlgrey.hjson `resets.nodes lc_io_div4`](hw/top_earlgrey/data/top_earlgrey.hjson)'''
            '''[top_earlgrey.hjson `resets.nodes sys_io_div4`](hw/top_earlgrey/data/top_earlgrey.hjson)'''
            '''[top_earlgrey.hjson `module.pinmux`](hw/top_earlgrey/data/top_earlgrey.hjson)'''
            '''[top_earlgrey_pinmux.ipconfig.hjson `enable_strap_sampling`](hw/top_earlgrey/ip_autogen/pinmux/data/top_earlgrey_pinmux.ipconfig.hjson)'''
          ]
          kind: "spec"
          testpoint: "dft_strap"
          checks: ["DFT straps held (assert_DftStrap_DftStrapsHeld)"]
          why: '''Once the valid bit is 1, it asserts the output unchanged into every next cycle not in full reset, whatever `lc_dft_en_i` and the pads do.'''
          milestone: "V2S"
          priority: "2"
          security: true
          state: "open"
        }
        {
          name: REQ_DFT_02b
          desc: '''Once valid, `dft_strap_test_o` shall keep its straps until a full reset.'''
          source: [
            '''[Strap Sampling and TAP Isolation](hw/top_earlgrey/ip_autogen/pinmux/doc/theory_of_operation.md#strap-sampling-and-tap-isolation)'''
            '''[Non-debug Module Reset](hw/top_earlgrey/ip_autogen/pinmux/doc/theory_of_operation.md#non-debug-module-reset)'''
            '''[top_earlgrey.hjson `resets.nodes lc_io_div4`](hw/top_earlgrey/data/top_earlgrey.hjson)'''
            '''[top_earlgrey.hjson `resets.nodes sys_io_div4`](hw/top_earlgrey/data/top_earlgrey.hjson)'''
            '''[top_earlgrey.hjson `module.pinmux`](hw/top_earlgrey/data/top_earlgrey.hjson)'''
            '''[top_earlgrey_pinmux.ipconfig.hjson `enable_strap_sampling`](hw/top_earlgrey/ip_autogen/pinmux/data/top_earlgrey_pinmux.ipconfig.hjson)'''
          ]
          kind: "spec"
          testpoint: "dft_strap"
          checks: ["DFT straps held (assert_DftStrap_DftStrapsHeld)"]
          why: '''Once the valid bit is 1, it asserts the two straps unchanged into every next cycle that is not in full reset.'''
          milestone: "V2S"
          priority: "2"
          security: true
          state: "open"
        }
        {
          name: REQ_DFT_03
          desc: '''Before a sample at a `strap_en_i` pulse with `lc_dft_en_i` On, `dft_strap_test_o` shall be all 0, whatever the DFT strap pads carry.'''
          source: [
            '''[chip_testplan.hjson `chip_sw_tap_strap_sampling`](hw/top_earlgrey/data/chip_testplan.hjson)'''
            '''[top_earlgrey.hjson `targets.asic.pinmux.special_signals`](hw/top_earlgrey/data/top_earlgrey.hjson)'''
            '''[top_earlgrey_pinmux.ipconfig.hjson `enable_strap_sampling`](hw/top_earlgrey/ip_autogen/pinmux/data/top_earlgrey_pinmux.ipconfig.hjson)'''
          ]
          kind: "spec"
          testpoint: "dft_strap"
          checks: ["zero until sampled (assert_DftStrap_ZeroUntilSampled)"]
          why: '''Until a strap pulse with `lc_dft_en_i` On in either of the two cycles before, it asserts every bit of `dft_strap_test_o` 0.'''
          milestone: "V2S"
          priority: "2"
          security: true
          state: "open"
        }
      ]
    }
    {
      name: '''Earl Grey 2'''
      conditions: [
        '''Every Earl Grey row holds on Earl Grey 2 over the Earl Grey 2 values and pads below, unless a row here replaces or extends it.'''
        '''Allowed pad, Main pad and Main off: Terms.'''
        '''Pads: TAP straps 0, 1 on IOC8, IOC5; DFT straps 0, 1 on SPI_HOST_D2, SPI_HOST_D3; TCK IOA5, TMS IOA0, TDI IOA4, TRST_N IOA6, TDO IOA1.'''
      ]
      requirements: [
        {
          name: REQ_EG2_01
          desc: '''MIO peripheral input `n` shall read 0 while `MIO_PERIPH_INSEL_n` is 2 + `p` and pad `p` is not allowed for `n`.'''
          source: [
            '''[Muxing Matrix](hw/top_earlgrey/ip_autogen/pinmux/doc/theory_of_operation.md#muxing-matrix)'''
            '''[Pinmux Configuration](hw/top_earlgrey/ip_autogen/pinmux/doc/programmers_guide.md#pinmux-configuration)'''
            '''!!MIO_PERIPH_INSEL.IN'''
          ]
          kind: "spec"
          testpoint: "sparse_insel"
          checks: ["unlisted pad reads zero (assert_SparseInsel_UnlistedPadReadsZero)"]
          why: '''The check compares the input with 0 while its input select is unlisted.'''
          milestone: "V2"
          priority: "2"
          security: false
          state: "open"
        }
        {
          name: REQ_EG2_02
          desc: '''MIO pad `p` shall be high-Z (output enable 0, output 0) while `MIO_OUTSEL_p` is 3 + `k` and output `k` is not allowed for `p`.'''
          source: [
            '''[Muxing Matrix](hw/top_earlgrey/ip_autogen/pinmux/doc/theory_of_operation.md#muxing-matrix)'''
            '''[Pinmux Configuration](hw/top_earlgrey/ip_autogen/pinmux/doc/programmers_guide.md#pinmux-configuration)'''
            '''!!MIO_OUTSEL.OUT'''
          ]
          kind: "spec"
          testpoint: "sparse_outsel"
          checks: ["unlisted output disables pad (assert_SparseOutsel_UnlistedOutputDisablesPad)", "disabled pad drives zero (assert_SparseOutsel_DisabledPadDrivesZero)"]
          why: '''The checks compare `oe` and `out` with 0 while the pad's output select is unlisted.'''
          milestone: "V2"
          priority: "2"
          security: false
          state: "open"
        }
        {
          name: REQ_EG2_04
          desc: '''A signal whose `pads` list is empty shall be allowed every pad.'''
          source: [
            '''[top_earlgrey.hjson `pinmux`](hw/top_earlgrey/data/top_earlgrey.hjson)'''
          ]
          kind: "spec"
          testpoint: "eg2_matrix"
          checks: ["drives selected output (assert_PadOutput_DrivesSelectedOutput)"]
          why: '''Run over the allowed pairs, the check pairs output 110, whose list is empty, with every MIO pad.'''
          milestone: "V2"
          priority: "2"
          security: false
          state: "open"
        }
        {
          name: REQ_EG2_10
          desc: '''Each input of `gpio0` and `gpio1` shall read what its input select names, and each pad whose output select names one of their outputs shall carry it.'''
          source: [
            '''[top_earlgrey.hjson `pinmux.signals`](hw/top_earlgrey/data/top_earlgrey.hjson)'''
          ]
          kind: "spec"
          testpoint: "eg2_matrix"
          checks: ["reads tie 0 (assert_PadListen_ReadsTie0)", "reads tie 1 (assert_PadListen_ReadsTie1)", "reads selected pad (assert_PadListen_ReadsSelectedPad)", "drives selected output (assert_PadOutput_DrivesSelectedOutput)"]
          why: '''Run over every input and output of both modules.'''
          milestone: "V2"
          priority: "2"
          security: false
          state: "open"
        }
        {
          name: REQ_EG2_11a
          desc: '''For a pad allowed for the signal, input select 2 + `p` shall read pad `p`, as on Earl Grey (`REQ_IN_03`).'''
          source: [
            '''[Muxing Matrix](hw/top_earlgrey/ip_autogen/pinmux/doc/theory_of_operation.md#muxing-matrix)'''
            '''!!MIO_PERIPH_INSEL.IN'''
          ]
          kind: "spec"
          testpoint: "eg2_matrix"
          checks: ["reads selected pad (assert_PadListen_ReadsSelectedPad)"]
          why: '''Run over the allowed pairs, the check compares the input with pad `p` while its input select is 2 + `p`.'''
          milestone: "V2"
          priority: "2"
          security: false
          state: "open"
        }
        {
          name: REQ_EG2_11b
          desc: '''For a pad allowed for the signal, output select 3 + `k` shall carry output `k`, as on Earl Grey (`REQ_OUT_04a`).'''
          source: [
            '''[Muxing Matrix](hw/top_earlgrey/ip_autogen/pinmux/doc/theory_of_operation.md#muxing-matrix)'''
            '''!!MIO_OUTSEL.OUT'''
          ]
          kind: "spec"
          testpoint: "eg2_matrix"
          checks: ["drives selected output (assert_PadOutput_DrivesSelectedOutput)"]
          why: '''Run over the allowed pairs, the check compares the pad's `out` with output `k` while its output select is 3 + `k`.'''
          milestone: "V2"
          priority: "2"
          security: false
          state: "open"
        }
        {
          name: REQ_EG2_11c
          desc: '''For a pad allowed for the signal, output select 3 + `k` shall carry output enable `k`, as on Earl Grey (`REQ_OUT_04b`).'''
          source: [
            '''[Muxing Matrix](hw/top_earlgrey/ip_autogen/pinmux/doc/theory_of_operation.md#muxing-matrix)'''
            '''!!MIO_OUTSEL.OUT'''
          ]
          kind: "spec"
          testpoint: "eg2_matrix"
          checks: ["drives selected output (assert_PadOutput_DrivesSelectedOutput)"]
          why: '''The same check compares the pad's `oe` with `periph_to_mio_oe_i[k]`.'''
          milestone: "V2"
          priority: "2"
          security: false
          state: "open"
        }
        {
          name: REQ_EG2_12a
          desc: '''For every input, whatever its list, input select 0 shall make the input read 0, as on Earl Grey (`REQ_IN_01`).'''
          source: [
          ]
          kind: "spec"
          testpoint: "eg2_matrix"
          checks: ["reads tie 0 (assert_PadListen_ReadsTie0)"]
          why: '''Run on every input, whatever its list, the check compares the input with 0 while its input select is 0.'''
          milestone: "V2"
          priority: "2"
          security: false
          state: "open"
        }
        {
          name: REQ_EG2_12b
          desc: '''For every input, whatever its list, input select 1 shall make the input read 1, as on Earl Grey (`REQ_IN_02`).'''
          source: [
          ]
          kind: "spec"
          testpoint: "eg2_matrix"
          checks: ["reads tie 1 (assert_PadListen_ReadsTie1)"]
          why: '''The same with 1 for input select 1, the one-pad signals included.'''
          milestone: "V2"
          priority: "2"
          security: false
          state: "open"
        }
        {
          name: REQ_EG2_12c
          desc: '''For every pad, whatever its list, output select 0 shall drive the pad 0, as on Earl Grey (`REQ_OUT_01a`, `REQ_OUT_01b`).'''
          source: [
          ]
          kind: "spec"
          testpoint: "eg2_matrix"
          checks: ["tie 0 drives 0 (assert_PadOutput_Tie0Drives0)"]
          why: '''Run on every MIO pad, whatever its list, the check compares (`out`, `oe`) with (0, 1) while the output select is 0.'''
          milestone: "V2"
          priority: "2"
          security: false
          state: "open"
        }
        {
          name: REQ_EG2_12d
          desc: '''For every pad, whatever its list, output select 1 shall drive the pad 1, as on Earl Grey (`REQ_OUT_02a`, `REQ_OUT_02b`).'''
          source: [
          ]
          kind: "spec"
          testpoint: "eg2_matrix"
          checks: ["tie 1 drives 1 (assert_PadOutput_Tie1Drives1)"]
          why: '''The same with (1, 1) for output select 1. A design that applies the pad list to the constants leaves the pad high-Z and fails it.'''
          milestone: "V2"
          priority: "2"
          security: false
          state: "open"
        }
        {
          name: REQ_EG2_12e
          desc: '''For every pad, whatever its list, output select 2 shall make the pad high-Z, output 0, as on Earl Grey (`REQ_OUT_03a`, `REQ_OUT_03b`).'''
          source: [
          ]
          kind: "spec"
          testpoint: "eg2_matrix"
          checks: ["select 2 is high-Z (assert_PadOutput_Select2IsHighZ)"]
          why: '''The same with (0, 0) for output select 2. A design that decodes 2 as an output or a constant enables the pad and fails it.'''
          milestone: "V2"
          priority: "2"
          security: false
          state: "open"
        }
        {
          name: REQ_EG2_03a
          desc: '''From reset until software writes it, each input select shall act at its signal's `default`: the input reads its default pad, 0 or 1, else 0. Replaces REQ_IN_06.'''
          source: [
            '''[top_earlgrey.hjson `pinmux`](hw/top_earlgrey/data/top_earlgrey.hjson)'''
          ]
          kind: "spec"
          testpoint: "eg2_default"
          checks: ["input starts at default (assert_Eg2Default_InputStartsAtDefault)"]
          why: '''From reset until its select is written, the check compares the input with the input's default value.'''
          milestone: "V2"
          priority: "2"
          security: false
          state: "open"
        }
        {
          name: REQ_EG2_03b
          desc: '''Until software writes it after reset, each MIO output select shall give its pad the output whose `default` names that pad, else high-Z. Replaces REQ_OUT_07.'''
          source: [
            '''[top_earlgrey.hjson `pinmux`](hw/top_earlgrey/data/top_earlgrey.hjson)'''
          ]
          kind: "spec"
          testpoint: "eg2_default"
          checks: ["pad starts at default (assert_Eg2Default_PadStartsAtDefault)"]
          why: '''From reset until its select is written, the check compares the pad with the pad's default drive.'''
          milestone: "V2"
          priority: "2"
          security: false
          state: "open"
        }
        {
          name: REQ_EG2_15
          desc: '''After reset, each pad's attribute output shall be its top entry's reset value (all 0 if no `attrs`), 0 in fields its type does not keep. Replaces REQ_ATTR_10.'''
          source: [
            '''[top_earlgrey.hjson `pinout`](hw/top_earlgrey/data/top_earlgrey.hjson)'''
          ]
          kind: "spec"
          testpoint: "eg2_attr_reset"
          checks: ["reset attributes (assert_PadAttr_ResetAttributes)"]
          why: '''Until the pad's first attribute write, the check compares its attribute output with its top attribute reset value.'''
          milestone: "V2"
          priority: "2"
          security: false
          state: "open"
        }
        {
          name: REQ_EG2_05
          desc: '''A detector whose `PADSEL` names a pad that is not wakeup capable shall watch 0.'''
          source: [
          ]
          kind: "spec"
          testpoint: "wkup_capable"
          checks: ["watched value off the list (assert_WkupCapable_WatchedValueOffTheList)"]
          why: '''The check applies the rule of `wakeup` with 0 watched, so a rise on the pad sets no cause.'''
          milestone: "V2"
          priority: "2"
          security: false
          state: "open"
        }
        {
          name: REQ_EG2_13
          desc: '''A detector shall watch the wakeup-capable pad it selects, encoded as on Earl Grey (`REQ_WKUP_01`, `REQ_WKUP_02`). With no pad marked, every pad is capable.'''
          source: [
          ]
          kind: "spec"
          testpoint: "wkup_capable"
          checks: ["wakeup rule on capable pads"]
          why: '''The checks of `wakeup` run on each wakeup-capable pad, every pad on a top that marks none.'''
          milestone: "V2"
          priority: "2"
          security: false
          state: "open"
        }
        {
          name: REQ_EG2_06a
          desc: '''After Main is off, every Main-section select shall act at its reset value until software writes it.'''
          source: [
          ]
          kind: "spec"
          testpoint: "split_reset"
          checks: ["Main selects on Main reset (check_SplitReset_MainSelectsOnMainReset)", "input starts at default (assert_Eg2Default_InputStartsAtDefault)", "pad starts at default (assert_Eg2Default_PadStartsAtDefault)"]
          why: '''Main off resets each Main select; eg2_default decides its value.'''
          milestone: "V2"
          priority: "2"
          security: false
          state: "open"
        }
        {
          name: REQ_EG2_06b
          desc: '''After Main is off, the lock of every Main-section select shall read 1 until software writes it.'''
          source: [
          ]
          kind: "spec"
          testpoint: "split_reset"
          checks: ["Main selects on Main reset (check_SplitReset_MainSelectsOnMainReset)", "the CSR checker"]
          why: '''Each Main lock takes the Main reset, and the CSR checker expects 1 after reset.'''
          milestone: "V2"
          priority: "2"
          security: false
          state: "open"
        }
        {
          name: REQ_EG2_07a
          desc: '''Main off shall change no AON-section select.'''
          source: [
          ]
          kind: "spec"
          testpoint: "split_reset"
          checks: ["AON state off Main reset (check_SplitReset_AonStateOffMainReset)", "the CSR checker"]
          why: '''The Main reset reaches no AON select's reset pin; the CSR checker allows a change only on an accepted write.'''
          milestone: "V2"
          priority: "2"
          security: false
          state: "open"
        }
        {
          name: REQ_EG2_07b
          desc: '''Main off shall change no AON-section lock.'''
          source: [
          ]
          kind: "spec"
          testpoint: "split_reset"
          checks: ["AON state off Main reset (check_SplitReset_AonStateOffMainReset)", "the CSR checker"]
          why: '''The Main reset reaches no AON lock's reset pin; the CSR checker allows a change only on an accepted write of 0.'''
          milestone: "V2"
          priority: "2"
          security: false
          state: "open"
        }
        {
          name: REQ_EG2_07c
          desc: '''Main off shall change no sleep status bit.'''
          source: [
          ]
          kind: "spec"
          testpoint: "split_reset"
          checks: ["AON state off Main reset (check_SplitReset_AonStateOffMainReset)", "bit set only at entry (assert_PadSleep_BitSetOnlyAtEntry)", "bit holds until cleared (assert_PadSleep_BitHoldsUntilCleared)"]
          why: '''No status bit takes the Main reset; the bit checks forbid other changes.'''
          milestone: "V2"
          priority: "2"
          security: false
          state: "open"
        }
        {
          name: REQ_EG2_08a
          desc: '''A pad whose status bit is 1 shall keep the sleep value its sleep mode sets (Sleep retention) while Main is off.'''
          source: [
          ]
          kind: "spec"
          testpoint: "split_reset"
          checks: ["held pads through Main off", "status bits through Main off"]
          why: '''With Main held off, a held pad that changes its drive or loses its status bit fails one.'''
          milestone: "V2"
          priority: "2"
          security: false
          state: "open"
        }
        {
          name: REQ_EG2_08b
          desc: '''A pad whose status bit is 1 shall keep the sleep value its sleep mode sets (Sleep retention) once Main is back.'''
          source: [
          ]
          kind: "spec"
          testpoint: "split_reset"
          checks: ["AON state off Main reset (check_SplitReset_AonStateOffMainReset)", "tie low in sleep (assert_PadSleep_TieLowInSleep)", "tie high in sleep (assert_PadSleep_TieHighInSleep)", "high-Z in sleep (assert_PadSleep_HighZInSleep)", "keep holds (assert_PadSleep_KeepHolds)"]
          why: '''No state of a held pad takes the Main reset.'''
          milestone: "V2"
          priority: "2"
          security: false
          state: "open"
        }
        {
          name: REQ_EG2_09a
          desc: '''While Main is off, the AON input selects shall keep their state, and each input they serve shall still read what its select names (Input selection).'''
          source: [
          ]
          kind: "spec"
          testpoint: "split_reset"
          checks: ["AON inputs in Main off", "AON registers hold in Main off (assert_SplitReset_AonRegistersHoldInMainOff)"]
          why: '''With Main held off, each AON input still reads what its select names, and the select holds.'''
          milestone: "V2"
          priority: "2"
          security: false
          state: "open"
        }
        {
          name: REQ_EG2_09b
          desc: '''While Main is off, the AON output selects shall keep their state, and each pad they serve shall still carry what its select names (Output selection).'''
          source: [
          ]
          kind: "spec"
          testpoint: "split_reset"
          checks: ["AON pads in Main off", "AON registers hold in Main off (assert_SplitReset_AonRegistersHoldInMainOff)"]
          why: '''With Main held off, each AON pad still carries what its select names, and the select holds.'''
          milestone: "V2"
          priority: "2"
          security: false
          state: "open"
        }
        {
          name: REQ_EG2_09c
          desc: '''While Main is off, the TAP straps shall keep their state and still be sampled from their pads (Strap sampling).'''
          source: [
          ]
          kind: "spec"
          testpoint: "split_reset"
          checks: ["straps in Main off"]
          why: '''With Main held off, each strap pulse still samples the strap pads, and the straps hold between pulses.'''
          milestone: "V2"
          priority: "2"
          security: false
          state: "open"
        }
        {
          name: REQ_EG2_09d
          desc: '''While Main is off, the latch shall keep its state, take the life cycle debug enable at each `strap_en_i` pulse and go Off on a clear (Latched debug enable).'''
          source: [
          ]
          kind: "spec"
          testpoint: "split_reset"
          checks: ["latch in Main off"]
          why: '''With Main held off, the latch still takes the debug enable at each strap pulse, goes Off on a clear and holds.'''
          milestone: "V2"
          priority: "2"
          security: false
          state: "open"
        }
        {
          name: REQ_EG2_09e
          desc: '''While Main is off, TAP selection shall keep its state, and the TAP the straps name shall still get the JTAG pads (TAP selection and the JTAG pads).'''
          source: [
          ]
          kind: "spec"
          testpoint: "split_reset"
          checks: ["TAPs in Main off"]
          why: '''With Main held off, the TAP the straps name still gets the JTAG pads, Main pads included, and the others zero.'''
          milestone: "V2"
          priority: "2"
          security: false
          state: "open"
        }
        {
          name: REQ_EG2_09f
          desc: '''While Main is off, the wakeup detectors shall keep their state; each shall detect in its mode on its watched signal and set its cause bit (Wakeup detectors).'''
          source: [
          ]
          kind: "spec"
          testpoint: "split_reset"
          checks: ["detectors in Main off"]
          why: '''With Main held off, each detector still watches its pad, detects in its mode and keeps its cause bit until cleared.'''
          milestone: "V2"
          priority: "2"
          security: false
          state: "open"
        }
        {
          name: REQ_EG2_14
          desc: '''While Main is off, a Main pad whose status bit is 0 and which no TAP owns shall carry what its output select gives at its reset value (`REQ_EG2_03b`).'''
          source: [
          ]
          kind: "spec"
          testpoint: "split_reset"
          checks: ["Main pad not held at default (assert_SplitReset_MainPadNotHeldAtDefault)"]
          why: '''With Main held off, the check compares each awake Main pad no TAP owns with the pad's default drive.'''
          milestone: "V2"
          priority: "2"
          security: false
          state: "open"
        }
      ]
    }
  ]
}
