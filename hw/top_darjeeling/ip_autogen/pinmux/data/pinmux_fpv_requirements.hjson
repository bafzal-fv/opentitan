// Copyright lowRISC contributors (OpenTitan project).
// Licensed under the Apache License, Version 2.0, see LICENSE for details.
// SPDX-License-Identifier: Apache-2.0
{
  name: "pinmux_fpv"
  // The requirements of the pinmux FPV testplan (doc/fpv/README.md), one entry each:
  //   name, desc   the requirement ID and its statement
  //   source      where the rule comes from: !!REGISTER.FIELD names a register field
  //               (reggen's form), a Markdown link names a document section or a key
  //   kind        "spec": a specification states the rule; "RTL": none does, and the
  //               rule follows the design's present behaviour or leaves the outcome
  //               to a specification question
  //   testpoint   its testpoint in pinmux_env_fpv_testplan.hjson
  //   checks      what decides it: "<check name> (<planned assertion>)", the CSR
  //               checker, another testbench, or a check out of scope or waiting
  //   why         why those checks prove it
  //   milestone   the verification stage of its testpoint: V1, V2 or V2S
  //   priority    the order of work within a stage: "1" before "2"
  //   security    true when a security property depends on it
  //   state       "open" until its checks are proven; with a reason where no check
  //               of this plan decides it
  // The file holds, besides the entries:
  //   written_for   the top the plan was written for and read against
  //   rendered_for  the top of this copy; other tops render it from the same
  //                 template with their own parameters, and their requirements
  //                 are not reviewed
  //   terms         the words the requirements use, each with its meaning
  //   groups        the requirements by feature; a group's conditions say when
  //                 its requirements hold and define its own words
  written_for: "earlgrey"
  rendered_for: "darjeeling"
  terms: [
    {
      name: '''`n`'''
      desc: '''MIO peripheral input (0 to 3)'''
    }
    {
      name: '''`k`'''
      desc: '''MIO peripheral output (0 to 4)'''
    }
    {
      name: '''`p`'''
      desc: '''MIO pad (0 to 11)'''
    }
    {
      name: '''`d`'''
      desc: '''DIO pad (0 to 72)'''
    }
    {
      name: '''Watched signal'''
      desc: '''The pad input that `MIODIO` and `PADSEL` pick'''
    }
    {
      name: '''Forwarded value'''
      desc: '''The watched signal sampled each `clk_aon_i` cycle, through the filter when `FILTER` is 1'''
    }
    {
      name: '''Asleep, awake'''
      desc: '''A pad is asleep while its sleep status bit is 1, awake while it is 0'''
    }
    {
      name: '''AON'''
      desc: '''The always-on domain: the logic on `clk_aon_i` and `rst_aon_ni`'''
    }
    {
      name: '''Lands'''
      desc: '''A written or sampled value lands in the cycle the register or flop it is meant for takes it'''
    }
    {
      name: '''Hardware write'''
      desc: '''A write to a register field made by the pinmux logic, not by software over the bus'''
    }
  ]
  groups: [
    {
      name: '''Input selection'''
      conditions: [
        '''every row holds in every cycle, except for a JTAG pad while a TAP owns it.'''
      ]
      requirements: [
        {
          name: REQ_IN_01
          desc: '''MIO peripheral input `n` shall read 0 while `MIO_PERIPH_INSEL_n` is 0.'''
          source: [
            '''!!MIO_PERIPH_INSEL.IN'''
          ]
          kind: "spec"
          testpoint: "pad_listen"
          checks: ["reads tie 0 (assert_PadListen_ReadsTie0)"]
          why: '''In every cycle the check compares each MIO peripheral input whose select is 0 with 0.'''
          milestone: "V1"
          priority: "1"
          security: false
          state: "open: not reviewed for this top"
        }
        {
          name: REQ_IN_02
          desc: '''MIO peripheral input `n` shall read 1 while `MIO_PERIPH_INSEL_n` is 1.'''
          source: [
            '''!!MIO_PERIPH_INSEL.IN'''
          ]
          kind: "spec"
          testpoint: "pad_listen"
          checks: ["reads tie 1 (assert_PadListen_ReadsTie1)"]
          why: '''In every cycle the check compares each MIO peripheral input whose select is 1 with 1.'''
          milestone: "V1"
          priority: "1"
          security: false
          state: "open: not reviewed for this top"
        }
        {
          name: REQ_IN_03
          desc: '''MIO peripheral input `n` shall read the input of MIO pad `p`, in the same cycle, while `MIO_PERIPH_INSEL_n` is 2 + `p` (`p` from 0 to 11).'''
          source: [
            '''!!MIO_PERIPH_INSEL.IN'''
            '''[top_darjeeling_pinmux.ipconfig.hjson `n_mio_pads`](hw/top_darjeeling/ip_autogen/pinmux/data/top_darjeeling_pinmux.ipconfig.hjson)'''
          ]
          kind: "spec"
          testpoint: "pad_listen"
          checks: ["reads selected pad (assert_PadListen_ReadsSelectedPad)"]
          why: '''For each select from 2 to 13 the check compares the input with `mio_in_i` of pad select minus 2, in the same cycle.'''
          milestone: "V1"
          priority: "1"
          security: false
          state: "open: not reviewed for this top"
        }
        {
          name: REQ_IN_04
          desc: '''MIO peripheral input `n` shall read 0 while `MIO_PERIPH_INSEL_n` is 14 to 15, the values that name no pad.'''
          source: [
            '''!!MIO_PERIPH_INSEL'''
            '''[top_darjeeling_pinmux.ipconfig.hjson `n_mio_pads`](hw/top_darjeeling/ip_autogen/pinmux/data/top_darjeeling_pinmux.ipconfig.hjson)'''
          ]
          kind: "RTL"
          testpoint: "pad_listen"
          checks: ["no pad reads 0 (assert_PadListen_NoPadReads0)"]
          why: '''For selects 14 to 15, which name no pad, the check compares the input with 0.'''
          milestone: "V1"
          priority: "1"
          security: false
          state: "open: not reviewed for this top"
        }
        {
          name: REQ_IN_05
          desc: '''DIO peripheral input `d` shall read the input of DIO pad `d`, in the same cycle, whatever the registers hold.'''
          source: [
            '''[MIO and DIO Signal Categories](hw/top_darjeeling/ip_autogen/pinmux/doc/theory_of_operation.md#mio-and-dio-signal-categories)'''
          ]
          kind: "spec"
          testpoint: "pad_listen"
          checks: ["DIO reads its pad (assert_PadListen_DioReadsItsPad)"]
          why: '''The check compares each DIO peripheral input with its own pad's `dio_in_i` in the same cycle, whatever the registers hold.'''
          milestone: "V1"
          priority: "1"
          security: false
          state: "open: not reviewed for this top"
        }
        {
          name: REQ_IN_06
          desc: '''After reset, every MIO peripheral input shall read 0 until software writes its select.'''
          source: [
            '''[Pinmux Configuration](hw/top_darjeeling/ip_autogen/pinmux/doc/programmers_guide.md#pinmux-configuration)'''
            '''[MIO and DIO Signal Categories](hw/top_darjeeling/ip_autogen/pinmux/doc/theory_of_operation.md#mio-and-dio-signal-categories)'''
            '''!!MIO_PERIPH_INSEL.IN'''
          ]
          kind: "spec"
          testpoint: "reset_state"
          checks: ["reads tie 0 (assert_PadListen_ReadsTie0)", "the CSR checker"]
          why: '''The CSR checker keeps each input select at 0 until written, and _reads tie 0_ makes such an input read 0.'''
          milestone: "V2"
          priority: "2"
          security: false
          state: "open: not reviewed for this top"
        }
      ]
    }
    {
      name: '''Output selection'''
      conditions: [
        '''every row holds while the pad's sleep mode is not active (Sleep retention) and no TAP owns the pad.'''
      ]
      requirements: [
        {
          name: REQ_OUT_01a
          desc: '''The output of MIO pad `p` shall be 0 while `MIO_OUTSEL_p` is 0.'''
          source: [
            '''!!MIO_OUTSEL.OUT'''
          ]
          kind: "spec"
          testpoint: "pad_output"
          checks: ["tie 0 drives 0 (assert_PadOutput_Tie0Drives0)"]
          why: '''While an awake pad's select is 0, the check compares the pad's output with 0 in every cycle.'''
          milestone: "V1"
          priority: "1"
          security: false
          state: "open: not reviewed for this top"
        }
        {
          name: REQ_OUT_01b
          desc: '''The output enable of MIO pad `p` shall be 1 while `MIO_OUTSEL_p` is 0, so the pad drives 0.'''
          source: [
            '''!!MIO_OUTSEL.OUT'''
          ]
          kind: "spec"
          testpoint: "pad_output"
          checks: ["tie 0 drives 0 (assert_PadOutput_Tie0Drives0)"]
          why: '''Under select 0 the check compares the pad's output enable with 1 in every cycle.'''
          milestone: "V1"
          priority: "1"
          security: false
          state: "open: not reviewed for this top"
        }
        {
          name: REQ_OUT_02a
          desc: '''The output of MIO pad `p` shall be 1 while `MIO_OUTSEL_p` is 1.'''
          source: [
            '''!!MIO_OUTSEL.OUT'''
          ]
          kind: "spec"
          testpoint: "pad_output"
          checks: ["tie 1 drives 1 (assert_PadOutput_Tie1Drives1)"]
          why: '''While an awake pad's select is 1, the check compares the pad's output with 1 in every cycle.'''
          milestone: "V1"
          priority: "1"
          security: false
          state: "open: not reviewed for this top"
        }
        {
          name: REQ_OUT_02b
          desc: '''The output enable of MIO pad `p` shall be 1 while `MIO_OUTSEL_p` is 1, so the pad drives 1.'''
          source: [
            '''!!MIO_OUTSEL.OUT'''
          ]
          kind: "spec"
          testpoint: "pad_output"
          checks: ["tie 1 drives 1 (assert_PadOutput_Tie1Drives1)"]
          why: '''Under select 1 the check compares the pad's output enable with 1 in every cycle.'''
          milestone: "V1"
          priority: "1"
          security: false
          state: "open: not reviewed for this top"
        }
        {
          name: REQ_OUT_03a
          desc: '''The output enable of MIO pad `p` shall be 0 while `MIO_OUTSEL_p` is 2: the pad is high-Z.'''
          source: [
            '''!!MIO_OUTSEL.OUT'''
          ]
          kind: "spec"
          testpoint: "pad_output"
          checks: ["select 2 is high-Z (assert_PadOutput_Select2IsHighZ)"]
          why: '''While an awake pad's select is 2, the check compares the pad's output enable with 0 in every cycle.'''
          milestone: "V1"
          priority: "1"
          security: false
          state: "open: not reviewed for this top"
        }
        {
          name: REQ_OUT_03b
          desc: '''The output of MIO pad `p` shall be 0 while `MIO_OUTSEL_p` is 2.'''
          source: [
            '''!!MIO_OUTSEL.OUT'''
          ]
          kind: "spec"
          testpoint: "pad_output"
          checks: ["select 2 is high-Z (assert_PadOutput_Select2IsHighZ)"]
          why: '''Under select 2 the check compares the pad's output with 0 in every cycle.'''
          milestone: "V1"
          priority: "1"
          security: false
          state: "open: not reviewed for this top"
        }
        {
          name: REQ_OUT_04a
          desc: '''MIO pad `p` shall carry peripheral output `k`, in the same cycle, while `MIO_OUTSEL_p` is 3 + `k` (`k` from 0 to 4).'''
          source: [
            '''!!MIO_OUTSEL.OUT'''
            '''[Muxing Matrix](hw/top_darjeeling/ip_autogen/pinmux/doc/theory_of_operation.md#muxing-matrix)'''
            '''[top_darjeeling_pinmux.ipconfig.hjson `n_mio_periph_out`](hw/top_darjeeling/ip_autogen/pinmux/data/top_darjeeling_pinmux.ipconfig.hjson)'''
          ]
          kind: "spec"
          testpoint: "pad_output"
          checks: ["drives selected output (assert_PadOutput_DrivesSelectedOutput)"]
          why: '''For each select from 3 to 7 the check compares the pad's output with `periph_to_mio_i[k]`, `k` the select minus 3, in the same cycle.'''
          milestone: "V1"
          priority: "1"
          security: false
          state: "open: not reviewed for this top"
        }
        {
          name: REQ_OUT_04b
          desc: '''MIO pad `p` shall carry output enable `k`, in the same cycle, while `MIO_OUTSEL_p` is 3 + `k` (`k` from 0 to 4).'''
          source: [
            '''!!MIO_OUTSEL.OUT'''
            '''[Muxing Matrix](hw/top_darjeeling/ip_autogen/pinmux/doc/theory_of_operation.md#muxing-matrix)'''
            '''[top_darjeeling_pinmux.ipconfig.hjson `n_mio_periph_out`](hw/top_darjeeling/ip_autogen/pinmux/data/top_darjeeling_pinmux.ipconfig.hjson)'''
          ]
          kind: "spec"
          testpoint: "pad_output"
          checks: ["drives selected output (assert_PadOutput_DrivesSelectedOutput)"]
          why: '''The check compares the pad's output enable with `periph_to_mio_oe_i[k]`, `k` as for the data, in the same cycle.'''
          milestone: "V1"
          priority: "1"
          security: false
          state: "open: not reviewed for this top"
        }
        {
          name: REQ_OUT_05a
          desc: '''The output enable of MIO pad `p` shall be 0 while `MIO_OUTSEL_p` is above 7 (no such value on this top), the values that name no peripheral output: the pad is high-Z.'''
          source: [
            '''!!MIO_OUTSEL'''
            '''[top_darjeeling_pinmux.ipconfig.hjson `n_mio_periph_out`](hw/top_darjeeling/ip_autogen/pinmux/data/top_darjeeling_pinmux.ipconfig.hjson)'''
          ]
          kind: "RTL"
          testpoint: "pad_output"
          checks: ["no output is high-Z (assert_PadOutput_NoOutputIsHighZ)"]
          why: '''For selects above 7 (no such value on this top), which name no output, the check compares the pad's output enable with 0.'''
          milestone: "V1"
          priority: "1"
          security: false
          state: "open: not reviewed for this top"
        }
        {
          name: REQ_OUT_05b
          desc: '''The output of MIO pad `p` shall be 0 while `MIO_OUTSEL_p` is above 7 (no such value on this top), the values that name no peripheral output.'''
          source: [
            '''!!MIO_OUTSEL'''
            '''[top_darjeeling_pinmux.ipconfig.hjson `n_mio_periph_out`](hw/top_darjeeling/ip_autogen/pinmux/data/top_darjeeling_pinmux.ipconfig.hjson)'''
          ]
          kind: "RTL"
          testpoint: "pad_output"
          checks: ["no output is high-Z (assert_PadOutput_NoOutputIsHighZ)"]
          why: '''For selects above 7 (no such value on this top) the check compares the pad's output with 0.'''
          milestone: "V1"
          priority: "1"
          security: false
          state: "open: not reviewed for this top"
        }
        {
          name: REQ_OUT_06a
          desc: '''DIO pad `d` shall carry its peripheral's output, in the same cycle.'''
          source: [
            '''[MIO and DIO Signal Categories](hw/top_darjeeling/ip_autogen/pinmux/doc/theory_of_operation.md#mio-and-dio-signal-categories)'''
          ]
          kind: "spec"
          testpoint: "pad_output"
          checks: ["DIO drives its peripheral (assert_PadOutput_DioDrivesItsPeripheral)"]
          why: '''The check compares each awake DIO pad's output with `periph_to_dio_i[d]` in the same cycle, whatever the registers hold.'''
          milestone: "V1"
          priority: "1"
          security: false
          state: "open: not reviewed for this top"
        }
        {
          name: REQ_OUT_06b
          desc: '''DIO pad `d` shall carry its peripheral's output enable, in the same cycle.'''
          source: [
            '''[MIO and DIO Signal Categories](hw/top_darjeeling/ip_autogen/pinmux/doc/theory_of_operation.md#mio-and-dio-signal-categories)'''
          ]
          kind: "spec"
          testpoint: "pad_output"
          checks: ["DIO drives its peripheral (assert_PadOutput_DioDrivesItsPeripheral)"]
          why: '''The check compares each awake DIO pad's output enable with `periph_to_dio_oe_i[d]` in the same cycle, whatever the registers hold.'''
          milestone: "V1"
          priority: "1"
          security: false
          state: "open: not reviewed for this top"
        }
        {
          name: REQ_OUT_07
          desc: '''After reset, every MIO pad shall be high-Z until software writes its select.'''
          source: [
            '''[MIO and DIO Signal Categories](hw/top_darjeeling/ip_autogen/pinmux/doc/theory_of_operation.md#mio-and-dio-signal-categories)'''
            '''[Pinmux Configuration](hw/top_darjeeling/ip_autogen/pinmux/doc/programmers_guide.md#pinmux-configuration)'''
            '''!!MIO_OUTSEL.OUT'''
          ]
          kind: "spec"
          testpoint: "reset_state"
          checks: ["select 2 is high-Z (assert_PadOutput_Select2IsHighZ)", "the CSR checker"]
          why: '''The CSR checker keeps each output select at 2 until written; _select 2 is high-Z_ then makes an awake pad high-Z.'''
          milestone: "V2"
          priority: "2"
          security: false
          state: "open: not reviewed for this top"
        }
      ]
    }
    {
      name: '''Pad attributes'''
      conditions: [
        '''every row holds in every cycle, asleep or awake, except on a JTAG pad while a TAP owns it. "Written" means a write the register block accepts, its lock open (Register locks); "reads back" means what a read of the register returns. A pad type "keeps" an attribute bit when its pads implement that bit ([Pad Attributes](hw/top_darjeeling/ip_autogen/pinmux/doc/programmers_guide.md#pad-attributes)), the same on every pad of the type and for good. A one-bit field is kept when its bit is; each bit of `slew_rate` and `drive_strength` is kept or not on its own ([Pad Attributes](hw/top_darjeeling/ip_autogen/pinmux/doc/programmers_guide.md#pad-attributes)).'''
      ]
      requirements: [
        {
          name: REQ_ATTR_01a
          desc: '''The attribute output of MIO pad `p` shall equal, in field `invert`, what `MIO_PAD_ATTR_p` reads back.'''
          source: [
            '''!!MIO_PAD_ATTR.invert'''
            '''[Type RW HWExt](util/reggen/README.md#type-rw-hwext)'''
            '''[Generic Pad Wrapper](hw/top_darjeeling/ip_autogen/pinmux/doc/theory_of_operation.md#generic-pad-wrapper)'''
          ]
          kind: "spec"
          testpoint: "pad_attr"
          checks: ["pad gets read-back (assert_PadAttr_PadGetsReadBack)"]
          why: '''In every cycle the check compares field `invert` of the pad's `mio_attr_o` with the read-back of `MIO_PAD_ATTR_p`.'''
          milestone: "V2"
          priority: "2"
          security: false
          state: "open: not reviewed for this top"
        }
        {
          name: REQ_ATTR_01b
          desc: '''The attribute output of MIO pad `p` shall equal, in field `virtual_od_en`, what `MIO_PAD_ATTR_p` reads back.'''
          source: [
            '''!!MIO_PAD_ATTR.virtual_od_en'''
            '''[Type RW HWExt](util/reggen/README.md#type-rw-hwext)'''
            '''[Generic Pad Wrapper](hw/top_darjeeling/ip_autogen/pinmux/doc/theory_of_operation.md#generic-pad-wrapper)'''
          ]
          kind: "spec"
          testpoint: "pad_attr"
          checks: ["pad gets read-back (assert_PadAttr_PadGetsReadBack)"]
          why: '''In every cycle the check compares field `virtual_od_en` of the pad's `mio_attr_o` with the read-back of `MIO_PAD_ATTR_p`.'''
          milestone: "V2"
          priority: "2"
          security: false
          state: "open: not reviewed for this top"
        }
        {
          name: REQ_ATTR_01c
          desc: '''The attribute output of MIO pad `p` shall equal, in field `pull_en`, what `MIO_PAD_ATTR_p` reads back.'''
          source: [
            '''!!MIO_PAD_ATTR.pull_en'''
            '''[Type RW HWExt](util/reggen/README.md#type-rw-hwext)'''
            '''[Generic Pad Wrapper](hw/top_darjeeling/ip_autogen/pinmux/doc/theory_of_operation.md#generic-pad-wrapper)'''
          ]
          kind: "spec"
          testpoint: "pad_attr"
          checks: ["pad gets read-back (assert_PadAttr_PadGetsReadBack)"]
          why: '''In every cycle the check compares field `pull_en` of the pad's `mio_attr_o` with the read-back of `MIO_PAD_ATTR_p`.'''
          milestone: "V2"
          priority: "2"
          security: false
          state: "open: not reviewed for this top"
        }
        {
          name: REQ_ATTR_01d
          desc: '''The attribute output of MIO pad `p` shall equal, in field `pull_select`, what `MIO_PAD_ATTR_p` reads back.'''
          source: [
            '''!!MIO_PAD_ATTR.pull_select'''
            '''[Type RW HWExt](util/reggen/README.md#type-rw-hwext)'''
            '''[Generic Pad Wrapper](hw/top_darjeeling/ip_autogen/pinmux/doc/theory_of_operation.md#generic-pad-wrapper)'''
          ]
          kind: "spec"
          testpoint: "pad_attr"
          checks: ["pad gets read-back (assert_PadAttr_PadGetsReadBack)"]
          why: '''In every cycle the check compares field `pull_select` of the pad's `mio_attr_o` with the same field of the read-back of `MIO_PAD_ATTR_p`.'''
          milestone: "V2"
          priority: "2"
          security: false
          state: "open: not reviewed for this top"
        }
        {
          name: REQ_ATTR_01e
          desc: '''The attribute output of MIO pad `p` shall equal, in field `keeper_en`, what `MIO_PAD_ATTR_p` reads back.'''
          source: [
            '''!!MIO_PAD_ATTR.keeper_en'''
            '''[Type RW HWExt](util/reggen/README.md#type-rw-hwext)'''
            '''[Generic Pad Wrapper](hw/top_darjeeling/ip_autogen/pinmux/doc/theory_of_operation.md#generic-pad-wrapper)'''
          ]
          kind: "spec"
          testpoint: "pad_attr"
          checks: ["pad gets read-back (assert_PadAttr_PadGetsReadBack)"]
          why: '''In every cycle the check compares field `keeper_en` of the pad's `mio_attr_o` with the read-back of `MIO_PAD_ATTR_p`.'''
          milestone: "V2"
          priority: "2"
          security: false
          state: "open: not reviewed for this top"
        }
        {
          name: REQ_ATTR_01f
          desc: '''The attribute output of MIO pad `p` shall equal, in field `schmitt_en`, what `MIO_PAD_ATTR_p` reads back.'''
          source: [
            '''!!MIO_PAD_ATTR.schmitt_en'''
            '''[Type RW HWExt](util/reggen/README.md#type-rw-hwext)'''
            '''[Generic Pad Wrapper](hw/top_darjeeling/ip_autogen/pinmux/doc/theory_of_operation.md#generic-pad-wrapper)'''
          ]
          kind: "spec"
          testpoint: "pad_attr"
          checks: ["pad gets read-back (assert_PadAttr_PadGetsReadBack)"]
          why: '''In every cycle the check compares field `schmitt_en` of the pad's `mio_attr_o` with the same field of the read-back of `MIO_PAD_ATTR_p`.'''
          milestone: "V2"
          priority: "2"
          security: false
          state: "open: not reviewed for this top"
        }
        {
          name: REQ_ATTR_01g
          desc: '''The attribute output of MIO pad `p` shall equal, in field `od_en`, what `MIO_PAD_ATTR_p` reads back.'''
          source: [
            '''!!MIO_PAD_ATTR.od_en'''
            '''[Type RW HWExt](util/reggen/README.md#type-rw-hwext)'''
            '''[Generic Pad Wrapper](hw/top_darjeeling/ip_autogen/pinmux/doc/theory_of_operation.md#generic-pad-wrapper)'''
          ]
          kind: "spec"
          testpoint: "pad_attr"
          checks: ["pad gets read-back (assert_PadAttr_PadGetsReadBack)"]
          why: '''In every cycle the check compares field `od_en` of the pad's `mio_attr_o` with the read-back of `MIO_PAD_ATTR_p`.'''
          milestone: "V2"
          priority: "2"
          security: false
          state: "open: not reviewed for this top"
        }
        {
          name: REQ_ATTR_01h
          desc: '''The attribute output of MIO pad `p` shall equal, in field `input_disable`, what `MIO_PAD_ATTR_p` reads back.'''
          source: [
            '''!!MIO_PAD_ATTR.input_disable'''
            '''[Type RW HWExt](util/reggen/README.md#type-rw-hwext)'''
            '''[Generic Pad Wrapper](hw/top_darjeeling/ip_autogen/pinmux/doc/theory_of_operation.md#generic-pad-wrapper)'''
          ]
          kind: "spec"
          testpoint: "pad_attr"
          checks: ["pad gets read-back (assert_PadAttr_PadGetsReadBack)"]
          why: '''In every cycle the check compares field `input_disable` of the pad's `mio_attr_o` with the read-back of `MIO_PAD_ATTR_p`.'''
          milestone: "V2"
          priority: "2"
          security: false
          state: "open: not reviewed for this top"
        }
        {
          name: REQ_ATTR_01i
          desc: '''The attribute output of MIO pad `p` shall equal, in field `slew_rate`, what `MIO_PAD_ATTR_p` reads back.'''
          source: [
            '''!!MIO_PAD_ATTR.slew_rate'''
            '''[Type RW HWExt](util/reggen/README.md#type-rw-hwext)'''
            '''[Generic Pad Wrapper](hw/top_darjeeling/ip_autogen/pinmux/doc/theory_of_operation.md#generic-pad-wrapper)'''
          ]
          kind: "spec"
          testpoint: "pad_attr"
          checks: ["pad gets read-back (assert_PadAttr_PadGetsReadBack)"]
          why: '''In every cycle the check compares both bits of field `slew_rate` of the pad's `mio_attr_o` with the read-back of `MIO_PAD_ATTR_p`.'''
          milestone: "V2"
          priority: "2"
          security: false
          state: "open: not reviewed for this top"
        }
        {
          name: REQ_ATTR_01j
          desc: '''The attribute output of MIO pad `p` shall equal, in field `drive_strength`, what `MIO_PAD_ATTR_p` reads back.'''
          source: [
            '''!!MIO_PAD_ATTR.drive_strength'''
            '''[Type RW HWExt](util/reggen/README.md#type-rw-hwext)'''
            '''[Generic Pad Wrapper](hw/top_darjeeling/ip_autogen/pinmux/doc/theory_of_operation.md#generic-pad-wrapper)'''
          ]
          kind: "spec"
          testpoint: "pad_attr"
          checks: ["pad gets read-back (assert_PadAttr_PadGetsReadBack)"]
          why: '''In every cycle the check compares the four bits of field `drive_strength` of the pad's `mio_attr_o` with the read-back of `MIO_PAD_ATTR_p`.'''
          milestone: "V2"
          priority: "2"
          security: false
          state: "open: not reviewed for this top"
        }
        {
          name: REQ_ATTR_02a
          desc: '''The attribute output of DIO pad `d` shall equal, in field `invert`, what `DIO_PAD_ATTR_d` reads back.'''
          source: [
            '''!!DIO_PAD_ATTR.invert'''
            '''[Type RW HWExt](util/reggen/README.md#type-rw-hwext)'''
            '''[Generic Pad Wrapper](hw/top_darjeeling/ip_autogen/pinmux/doc/theory_of_operation.md#generic-pad-wrapper)'''
          ]
          kind: "spec"
          testpoint: "pad_attr"
          checks: ["pad gets read-back (assert_PadAttr_PadGetsReadBack)"]
          why: '''In every cycle the check compares field `invert` of the pad's `dio_attr_o` with the read-back of `DIO_PAD_ATTR_d`.'''
          milestone: "V2"
          priority: "2"
          security: false
          state: "open: not reviewed for this top"
        }
        {
          name: REQ_ATTR_02b
          desc: '''The attribute output of DIO pad `d` shall equal, in field `virtual_od_en`, what `DIO_PAD_ATTR_d` reads back.'''
          source: [
            '''!!DIO_PAD_ATTR.virtual_od_en'''
            '''[Type RW HWExt](util/reggen/README.md#type-rw-hwext)'''
            '''[Generic Pad Wrapper](hw/top_darjeeling/ip_autogen/pinmux/doc/theory_of_operation.md#generic-pad-wrapper)'''
          ]
          kind: "spec"
          testpoint: "pad_attr"
          checks: ["pad gets read-back (assert_PadAttr_PadGetsReadBack)"]
          why: '''In every cycle the check compares field `virtual_od_en` of the pad's `dio_attr_o` with the read-back of `DIO_PAD_ATTR_d`.'''
          milestone: "V2"
          priority: "2"
          security: false
          state: "open: not reviewed for this top"
        }
        {
          name: REQ_ATTR_02c
          desc: '''The attribute output of DIO pad `d` shall equal, in field `pull_en`, what `DIO_PAD_ATTR_d` reads back.'''
          source: [
            '''!!DIO_PAD_ATTR.pull_en'''
            '''[Type RW HWExt](util/reggen/README.md#type-rw-hwext)'''
            '''[Generic Pad Wrapper](hw/top_darjeeling/ip_autogen/pinmux/doc/theory_of_operation.md#generic-pad-wrapper)'''
          ]
          kind: "spec"
          testpoint: "pad_attr"
          checks: ["pad gets read-back (assert_PadAttr_PadGetsReadBack)"]
          why: '''In every cycle the check compares field `pull_en` of the pad's `dio_attr_o` with the read-back of `DIO_PAD_ATTR_d`.'''
          milestone: "V2"
          priority: "2"
          security: false
          state: "open: not reviewed for this top"
        }
        {
          name: REQ_ATTR_02d
          desc: '''The attribute output of DIO pad `d` shall equal, in field `pull_select`, what `DIO_PAD_ATTR_d` reads back.'''
          source: [
            '''!!DIO_PAD_ATTR.pull_select'''
            '''[Type RW HWExt](util/reggen/README.md#type-rw-hwext)'''
            '''[Generic Pad Wrapper](hw/top_darjeeling/ip_autogen/pinmux/doc/theory_of_operation.md#generic-pad-wrapper)'''
          ]
          kind: "spec"
          testpoint: "pad_attr"
          checks: ["pad gets read-back (assert_PadAttr_PadGetsReadBack)"]
          why: '''In every cycle the check compares field `pull_select` of the pad's `dio_attr_o` with the same field of the read-back of `DIO_PAD_ATTR_d`.'''
          milestone: "V2"
          priority: "2"
          security: false
          state: "open: not reviewed for this top"
        }
        {
          name: REQ_ATTR_02e
          desc: '''The attribute output of DIO pad `d` shall equal, in field `keeper_en`, what `DIO_PAD_ATTR_d` reads back.'''
          source: [
            '''!!DIO_PAD_ATTR.keeper_en'''
            '''[Type RW HWExt](util/reggen/README.md#type-rw-hwext)'''
            '''[Generic Pad Wrapper](hw/top_darjeeling/ip_autogen/pinmux/doc/theory_of_operation.md#generic-pad-wrapper)'''
          ]
          kind: "spec"
          testpoint: "pad_attr"
          checks: ["pad gets read-back (assert_PadAttr_PadGetsReadBack)"]
          why: '''In every cycle the check compares field `keeper_en` of the pad's `dio_attr_o` with the read-back of `DIO_PAD_ATTR_d`.'''
          milestone: "V2"
          priority: "2"
          security: false
          state: "open: not reviewed for this top"
        }
        {
          name: REQ_ATTR_02f
          desc: '''The attribute output of DIO pad `d` shall equal, in field `schmitt_en`, what `DIO_PAD_ATTR_d` reads back.'''
          source: [
            '''!!DIO_PAD_ATTR.schmitt_en'''
            '''[Type RW HWExt](util/reggen/README.md#type-rw-hwext)'''
            '''[Generic Pad Wrapper](hw/top_darjeeling/ip_autogen/pinmux/doc/theory_of_operation.md#generic-pad-wrapper)'''
          ]
          kind: "spec"
          testpoint: "pad_attr"
          checks: ["pad gets read-back (assert_PadAttr_PadGetsReadBack)"]
          why: '''In every cycle the check compares field `schmitt_en` of the pad's `dio_attr_o` with the same field of the read-back of `DIO_PAD_ATTR_d`.'''
          milestone: "V2"
          priority: "2"
          security: false
          state: "open: not reviewed for this top"
        }
        {
          name: REQ_ATTR_02g
          desc: '''The attribute output of DIO pad `d` shall equal, in field `od_en`, what `DIO_PAD_ATTR_d` reads back.'''
          source: [
            '''!!DIO_PAD_ATTR.od_en'''
            '''[Type RW HWExt](util/reggen/README.md#type-rw-hwext)'''
            '''[Generic Pad Wrapper](hw/top_darjeeling/ip_autogen/pinmux/doc/theory_of_operation.md#generic-pad-wrapper)'''
          ]
          kind: "spec"
          testpoint: "pad_attr"
          checks: ["pad gets read-back (assert_PadAttr_PadGetsReadBack)"]
          why: '''In every cycle the check compares field `od_en` of the pad's `dio_attr_o` with the read-back of `DIO_PAD_ATTR_d`.'''
          milestone: "V2"
          priority: "2"
          security: false
          state: "open: not reviewed for this top"
        }
        {
          name: REQ_ATTR_02h
          desc: '''The attribute output of DIO pad `d` shall equal, in field `input_disable`, what `DIO_PAD_ATTR_d` reads back.'''
          source: [
            '''!!DIO_PAD_ATTR.input_disable'''
            '''[Type RW HWExt](util/reggen/README.md#type-rw-hwext)'''
            '''[Generic Pad Wrapper](hw/top_darjeeling/ip_autogen/pinmux/doc/theory_of_operation.md#generic-pad-wrapper)'''
          ]
          kind: "spec"
          testpoint: "pad_attr"
          checks: ["pad gets read-back (assert_PadAttr_PadGetsReadBack)"]
          why: '''In every cycle the check compares field `input_disable` of the pad's `dio_attr_o` with the read-back of `DIO_PAD_ATTR_d`.'''
          milestone: "V2"
          priority: "2"
          security: false
          state: "open: not reviewed for this top"
        }
        {
          name: REQ_ATTR_02i
          desc: '''The attribute output of DIO pad `d` shall equal, in field `slew_rate`, what `DIO_PAD_ATTR_d` reads back.'''
          source: [
            '''!!DIO_PAD_ATTR.slew_rate'''
            '''[Type RW HWExt](util/reggen/README.md#type-rw-hwext)'''
            '''[Generic Pad Wrapper](hw/top_darjeeling/ip_autogen/pinmux/doc/theory_of_operation.md#generic-pad-wrapper)'''
          ]
          kind: "spec"
          testpoint: "pad_attr"
          checks: ["pad gets read-back (assert_PadAttr_PadGetsReadBack)"]
          why: '''In every cycle the check compares both bits of field `slew_rate` of the pad's `dio_attr_o` with the read-back of `DIO_PAD_ATTR_d`.'''
          milestone: "V2"
          priority: "2"
          security: false
          state: "open: not reviewed for this top"
        }
        {
          name: REQ_ATTR_02j
          desc: '''The attribute output of DIO pad `d` shall equal, in field `drive_strength`, what `DIO_PAD_ATTR_d` reads back.'''
          source: [
            '''!!DIO_PAD_ATTR.drive_strength'''
            '''[Type RW HWExt](util/reggen/README.md#type-rw-hwext)'''
            '''[Generic Pad Wrapper](hw/top_darjeeling/ip_autogen/pinmux/doc/theory_of_operation.md#generic-pad-wrapper)'''
          ]
          kind: "spec"
          testpoint: "pad_attr"
          checks: ["pad gets read-back (assert_PadAttr_PadGetsReadBack)"]
          why: '''In every cycle the check compares the four bits of field `drive_strength` of the pad's `dio_attr_o` with the read-back of `DIO_PAD_ATTR_d`.'''
          milestone: "V2"
          priority: "2"
          security: false
          state: "open: not reviewed for this top"
        }
        {
          name: REQ_ATTR_03
          desc: '''The `invert` field of every pad shall read back as written.'''
          source: [
            '''[Generic Pad Wrapper](hw/top_darjeeling/ip_autogen/pinmux/doc/theory_of_operation.md#generic-pad-wrapper)'''
          ]
          kind: "spec"
          testpoint: "pad_attr"
          checks: ["invert reads back (assert_PadAttr_InvertReadsBack)"]
          why: '''On every pad type, the check compares the `invert` bit of the read-back with that of the pad's last attribute write.'''
          milestone: "V2"
          priority: "2"
          security: false
          state: "open: not reviewed for this top"
        }
        {
          name: REQ_ATTR_04
          desc: '''The `od_en` field of a BidirOd pad shall read back as written.'''
          source: [
            '''[Open drain / virtual open drain](hw/top_earlgrey/doc/design/README.md#open-drain--virtual-open-drain)'''
            '''[top_darjeeling.hjson](hw/top_darjeeling/data/top_darjeeling.hjson)'''
          ]
          kind: "spec"
          testpoint: "pad_attr"
          checks: ["open drain reads back (assert_PadAttr_OpenDrainReadsBack)"]
          why: '''On every BidirOd pad, the check compares the `od_en` bit of the read-back with that of the pad's last attribute write.'''
          milestone: "V2"
          priority: "2"
          security: false
          state: "open: not reviewed for this top"
        }
        {
          name: REQ_ATTR_05
          desc: '''The `virtual_od_en` field of a BidirStd pad shall read back as written.'''
          source: [
            '''[Open drain / virtual open drain](hw/top_earlgrey/doc/design/README.md#open-drain--virtual-open-drain)'''
            '''[top_darjeeling.hjson](hw/top_darjeeling/data/top_darjeeling.hjson)'''
          ]
          kind: "spec"
          testpoint: "pad_attr"
          checks: ["virtual open drain reads back (assert_PadAttr_VirtualOpenDrainReadsBack)"]
          why: '''On every BidirStd pad, the check compares the `virtual_od_en` bit of the read-back with that of the last attribute write.'''
          milestone: "V2"
          priority: "2"
          security: false
          state: "open: not reviewed for this top"
        }
        {
          name: REQ_ATTR_06
          desc: '''The `od_en` field of every pad not of type BidirOd shall read back 0.'''
          source: [
            '''[Open drain / virtual open drain](hw/top_earlgrey/doc/design/README.md#open-drain--virtual-open-drain)'''
            '''[Pad Attributes](hw/top_darjeeling/ip_autogen/pinmux/doc/programmers_guide.md#pad-attributes)'''
            '''[top_darjeeling.hjson](hw/top_darjeeling/data/top_darjeeling.hjson)'''
          ]
          kind: "spec"
          testpoint: "pad_attr"
          checks: ["no open drain elsewhere (assert_PadAttr_NoOpenDrainElsewhere)"]
          why: '''On every pad not of type BidirOd, the check requires the `od_en` bit of the read-back to be 0, whatever software wrote.'''
          milestone: "V2"
          priority: "2"
          security: false
          state: "open: not reviewed for this top"
        }
        {
          name: REQ_ATTR_07
          desc: '''The `virtual_od_en` field of every pad not of type BidirStd shall read back 0.'''
          source: [
            '''[Open drain / virtual open drain](hw/top_earlgrey/doc/design/README.md#open-drain--virtual-open-drain)'''
            '''[Pad Attributes](hw/top_darjeeling/ip_autogen/pinmux/doc/programmers_guide.md#pad-attributes)'''
            '''[top_darjeeling.hjson](hw/top_darjeeling/data/top_darjeeling.hjson)'''
          ]
          kind: "spec"
          testpoint: "pad_attr"
          checks: ["no virtual open drain elsewhere (assert_PadAttr_NoVirtualOpenDrainElsewhere)"]
          why: '''On every pad not of type BidirStd, the check requires the `virtual_od_en` bit of the read-back to be 0, whatever software wrote.'''
          milestone: "V2"
          priority: "2"
          security: false
          state: "open: not reviewed for this top"
        }
        {
          name: REQ_ATTR_08c
          desc: '''The field `pull_en` shall read back as written where the pad's type keeps the field.'''
          source: [
            '''!!MIO_PAD_ATTR'''
            '''[Pad Attributes](hw/top_darjeeling/ip_autogen/pinmux/doc/programmers_guide.md#pad-attributes)'''
            '''[top_darjeeling.hjson](hw/top_darjeeling/data/top_darjeeling.hjson)'''
          ]
          kind: "spec"
          testpoint: "pad_attr"
          checks: ["supported bits read back (assert_PadAttr_SupportedBitsReadBack)"]
          why: '''The check requires `pull_en` to read back a written 0, and a written 1 once a pad of its type has read one back.'''
          milestone: "V2"
          priority: "2"
          security: false
          state: "open: not reviewed for this top"
        }
        {
          name: REQ_ATTR_08d
          desc: '''The field `pull_select` shall read back as written where the pad's type keeps the field.'''
          source: [
            '''!!MIO_PAD_ATTR'''
            '''[Pad Attributes](hw/top_darjeeling/ip_autogen/pinmux/doc/programmers_guide.md#pad-attributes)'''
            '''[top_darjeeling.hjson](hw/top_darjeeling/data/top_darjeeling.hjson)'''
          ]
          kind: "spec"
          testpoint: "pad_attr"
          checks: ["supported bits read back (assert_PadAttr_SupportedBitsReadBack)"]
          why: '''The check requires `pull_select` to read back a written 0, and a written 1 once a pad of its type has read one back.'''
          milestone: "V2"
          priority: "2"
          security: false
          state: "open: not reviewed for this top"
        }
        {
          name: REQ_ATTR_08e
          desc: '''The field `keeper_en` shall read back as written where the pad's type keeps the field.'''
          source: [
            '''!!MIO_PAD_ATTR'''
            '''[Pad Attributes](hw/top_darjeeling/ip_autogen/pinmux/doc/programmers_guide.md#pad-attributes)'''
            '''[top_darjeeling.hjson](hw/top_darjeeling/data/top_darjeeling.hjson)'''
          ]
          kind: "spec"
          testpoint: "pad_attr"
          checks: ["supported bits read back (assert_PadAttr_SupportedBitsReadBack)"]
          why: '''The check requires `keeper_en` to read back a written 0, and a written 1 once a pad of its type has read one back.'''
          milestone: "V2"
          priority: "2"
          security: false
          state: "open: not reviewed for this top"
        }
        {
          name: REQ_ATTR_08f
          desc: '''The field `schmitt_en` shall read back as written where the pad's type keeps the field.'''
          source: [
            '''!!MIO_PAD_ATTR'''
            '''[Pad Attributes](hw/top_darjeeling/ip_autogen/pinmux/doc/programmers_guide.md#pad-attributes)'''
            '''[top_darjeeling.hjson](hw/top_darjeeling/data/top_darjeeling.hjson)'''
          ]
          kind: "spec"
          testpoint: "pad_attr"
          checks: ["supported bits read back (assert_PadAttr_SupportedBitsReadBack)"]
          why: '''The check requires `schmitt_en` to read back a written 0, and a written 1 once a pad of its type has read one back.'''
          milestone: "V2"
          priority: "2"
          security: false
          state: "open: not reviewed for this top"
        }
        {
          name: REQ_ATTR_08g
          desc: '''The field `input_disable` shall read back as written where the pad's type keeps the field.'''
          source: [
            '''!!MIO_PAD_ATTR'''
            '''[Pad Attributes](hw/top_darjeeling/ip_autogen/pinmux/doc/programmers_guide.md#pad-attributes)'''
            '''[top_darjeeling.hjson](hw/top_darjeeling/data/top_darjeeling.hjson)'''
          ]
          kind: "spec"
          testpoint: "pad_attr"
          checks: ["supported bits read back (assert_PadAttr_SupportedBitsReadBack)"]
          why: '''The check requires `input_disable` to read back a written 0, and a written 1 once a pad of its type has read one back.'''
          milestone: "V2"
          priority: "2"
          security: false
          state: "open: not reviewed for this top"
        }
        {
          name: REQ_ATTR_08h
          desc: '''Each bit of the field `slew_rate` shall read back as written where the pad's type keeps that bit.'''
          source: [
            '''!!MIO_PAD_ATTR'''
            '''[Pad Attributes](hw/top_darjeeling/ip_autogen/pinmux/doc/programmers_guide.md#pad-attributes)'''
            '''[top_darjeeling.hjson](hw/top_darjeeling/data/top_darjeeling.hjson)'''
          ]
          kind: "spec"
          testpoint: "pad_attr"
          checks: ["supported bits read back (assert_PadAttr_SupportedBitsReadBack)"]
          why: '''The check requires each bit of `slew_rate` to read back a written 0, and a written 1 once a pad of its type has read one back.'''
          milestone: "V2"
          priority: "2"
          security: false
          state: "open: not reviewed for this top"
        }
        {
          name: REQ_ATTR_08i
          desc: '''Each bit of the field `drive_strength` shall read back as written where the pad's type keeps that bit.'''
          source: [
            '''!!MIO_PAD_ATTR'''
            '''[Pad Attributes](hw/top_darjeeling/ip_autogen/pinmux/doc/programmers_guide.md#pad-attributes)'''
            '''[top_darjeeling.hjson](hw/top_darjeeling/data/top_darjeeling.hjson)'''
          ]
          kind: "spec"
          testpoint: "pad_attr"
          checks: ["supported bits read back (assert_PadAttr_SupportedBitsReadBack)"]
          why: '''The check requires each bit of `drive_strength` to read back a written 0, and a written 1 once a pad of its type has read one back.'''
          milestone: "V2"
          priority: "2"
          security: false
          state: "open: not reviewed for this top"
        }
        {
          name: REQ_ATTR_09c
          desc: '''The field `pull_en` shall read back 0 where the pad's type does not keep the field.'''
          source: [
            '''[Pad Attributes](hw/top_darjeeling/ip_autogen/pinmux/doc/programmers_guide.md#pad-attributes)'''
            '''[top_darjeeling.hjson](hw/top_darjeeling/data/top_darjeeling.hjson)'''
          ]
          kind: "spec"
          testpoint: "pad_attr"
          checks: ["unsupported bits read 0 (assert_PadAttr_UnsupportedBitsRead0)"]
          why: '''The check requires `pull_en` to read back a written 0, and 0 on every pad of its type once one read a written 1 as 0.'''
          milestone: "V2"
          priority: "2"
          security: false
          state: "open: not reviewed for this top"
        }
        {
          name: REQ_ATTR_09d
          desc: '''The field `pull_select` shall read back 0 where the pad's type does not keep the field.'''
          source: [
            '''[Pad Attributes](hw/top_darjeeling/ip_autogen/pinmux/doc/programmers_guide.md#pad-attributes)'''
            '''[top_darjeeling.hjson](hw/top_darjeeling/data/top_darjeeling.hjson)'''
          ]
          kind: "spec"
          testpoint: "pad_attr"
          checks: ["unsupported bits read 0 (assert_PadAttr_UnsupportedBitsRead0)"]
          why: '''The check requires `pull_select` to read back a written 0, and 0 on every pad of its type once one read a written 1 as 0.'''
          milestone: "V2"
          priority: "2"
          security: false
          state: "open: not reviewed for this top"
        }
        {
          name: REQ_ATTR_09e
          desc: '''The field `keeper_en` shall read back 0 where the pad's type does not keep the field.'''
          source: [
            '''[Pad Attributes](hw/top_darjeeling/ip_autogen/pinmux/doc/programmers_guide.md#pad-attributes)'''
            '''[top_darjeeling.hjson](hw/top_darjeeling/data/top_darjeeling.hjson)'''
          ]
          kind: "spec"
          testpoint: "pad_attr"
          checks: ["unsupported bits read 0 (assert_PadAttr_UnsupportedBitsRead0)"]
          why: '''The check requires `keeper_en` to read back a written 0, and 0 on every pad of its type once one read a written 1 as 0.'''
          milestone: "V2"
          priority: "2"
          security: false
          state: "open: not reviewed for this top"
        }
        {
          name: REQ_ATTR_09f
          desc: '''The field `schmitt_en` shall read back 0 where the pad's type does not keep the field.'''
          source: [
            '''[Pad Attributes](hw/top_darjeeling/ip_autogen/pinmux/doc/programmers_guide.md#pad-attributes)'''
            '''[top_darjeeling.hjson](hw/top_darjeeling/data/top_darjeeling.hjson)'''
          ]
          kind: "spec"
          testpoint: "pad_attr"
          checks: ["unsupported bits read 0 (assert_PadAttr_UnsupportedBitsRead0)"]
          why: '''The check requires `schmitt_en` to read back a written 0, and 0 on every pad of its type once one read a written 1 as 0.'''
          milestone: "V2"
          priority: "2"
          security: false
          state: "open: not reviewed for this top"
        }
        {
          name: REQ_ATTR_09g
          desc: '''The field `input_disable` shall read back 0 where the pad's type does not keep the field.'''
          source: [
            '''[Pad Attributes](hw/top_darjeeling/ip_autogen/pinmux/doc/programmers_guide.md#pad-attributes)'''
            '''[top_darjeeling.hjson](hw/top_darjeeling/data/top_darjeeling.hjson)'''
          ]
          kind: "spec"
          testpoint: "pad_attr"
          checks: ["unsupported bits read 0 (assert_PadAttr_UnsupportedBitsRead0)"]
          why: '''The check requires `input_disable` to read back a written 0, and 0 on every pad of its type once one read a written 1 as 0.'''
          milestone: "V2"
          priority: "2"
          security: false
          state: "open: not reviewed for this top"
        }
        {
          name: REQ_ATTR_09h
          desc: '''Each bit of the field `slew_rate` shall read back 0 where the pad's type does not keep that bit.'''
          source: [
            '''[Pad Attributes](hw/top_darjeeling/ip_autogen/pinmux/doc/programmers_guide.md#pad-attributes)'''
            '''[top_darjeeling.hjson](hw/top_darjeeling/data/top_darjeeling.hjson)'''
          ]
          kind: "spec"
          testpoint: "pad_attr"
          checks: ["unsupported bits read 0 (assert_PadAttr_UnsupportedBitsRead0)"]
          why: '''The check requires each bit of `slew_rate` to read back a written 0, and 0 on every pad of its type once one read a written 1 as 0.'''
          milestone: "V2"
          priority: "2"
          security: false
          state: "open: not reviewed for this top"
        }
        {
          name: REQ_ATTR_09i
          desc: '''Each bit of the field `drive_strength` shall read back 0 where the pad's type does not keep that bit.'''
          source: [
            '''[Pad Attributes](hw/top_darjeeling/ip_autogen/pinmux/doc/programmers_guide.md#pad-attributes)'''
            '''[top_darjeeling.hjson](hw/top_darjeeling/data/top_darjeeling.hjson)'''
          ]
          kind: "spec"
          testpoint: "pad_attr"
          checks: ["unsupported bits read 0 (assert_PadAttr_UnsupportedBitsRead0)"]
          why: '''The check requires each bit of `drive_strength` to read back a written 0, and 0 on every pad of its type once one read a written 1 as 0.'''
          milestone: "V2"
          priority: "2"
          security: false
          state: "open: not reviewed for this top"
        }
        {
          name: REQ_ATTR_10
          desc: '''After reset, each pad's attribute output shall be its reset value, 0 in fields its type does not keep. All are 0 but the fields the `attrs` of the pad's top entry set.'''
          source: [
            '''!!MIO_PAD_ATTR'''
            '''!!DIO_PAD_ATTR'''
            '''[top_darjeeling.hjson](hw/top_darjeeling/data/top_darjeeling.hjson)'''
            '''[top_darjeeling.hjson](hw/top_darjeeling/data/top_darjeeling.hjson)'''
            '''[top_darjeeling.hjson](hw/top_darjeeling/data/top_darjeeling.hjson)'''
          ]
          kind: "spec"
          testpoint: "pad_attr"
          checks: ["reset attributes (assert_PadAttr_ResetAttributes)"]
          why: '''Until the pad's first attribute write after reset, the check compares the pad's attribute output with the reset attributes.'''
          milestone: "V2"
          priority: "2"
          security: false
          state: "open: not reviewed for this top"
        }
      ]
    }
    {
      name: '''Sleep retention'''
      conditions: [
        '''"pad" is MIO pad `p` or DIO pad `d`; "status bit" is its bit in `MIO_PAD_SLEEP_STATUS` or `DIO_PAD_SLEEP_STATUS`. "Sleep entry" is a rise of `sleep_en_i`. The mode rows hold while no TAP owns the pad and the sleep mode is unchanged since sleep entry.'''
      ]
      requirements: [
        {
          name: REQ_SLP_01
          desc: '''At sleep entry, the status bit of every pad whose sleep enable is 1 shall become 1, unless a software clear of that bit lands in the same cycle (`REQ_SLP_09`).'''
          source: [
            '''!!MIO_PAD_SLEEP_EN.EN'''
            '''[Sleep Features](hw/top_darjeeling/ip_autogen/pinmux/doc/programmers_guide.md#sleep-features)'''
          ]
          kind: "spec"
          testpoint: "pad_sleep"
          checks: ["bit set at entry (assert_PadSleep_BitSetAtEntry)"]
          why: '''For every sleep entry with the sleep enable at 1 and no software clear of the bit, the check requires the status bit to be 1 in the next cycle.'''
          milestone: "V2"
          priority: "2"
          security: false
          state: "open: not reviewed for this top"
        }
        {
          name: REQ_SLP_02
          desc: '''A status bit shall become 1 only at sleep entry, and only if the pad's sleep enable is 1.'''
          source: [
            '''!!MIO_PAD_SLEEP_STATUS.EN'''
            '''[Sleep Features](hw/top_darjeeling/ip_autogen/pinmux/doc/programmers_guide.md#sleep-features)'''
          ]
          kind: "spec"
          testpoint: "pad_sleep"
          checks: ["bit set only at entry (assert_PadSleep_BitSetOnlyAtEntry)"]
          why: '''For every rise of a status bit the check requires a sleep entry with the pad's sleep enable at 1 in the cycle before.'''
          milestone: "V2"
          priority: "2"
          security: false
          state: "open: not reviewed for this top"
        }
        {
          name: REQ_SLP_03a
          desc: '''While its status bit is 1 and its sleep mode is 0, a pad's output shall be 0.'''
          source: [
            '''!!MIO_PAD_SLEEP_MODE.OUT'''
            '''[Sleep Features](hw/top_darjeeling/ip_autogen/pinmux/doc/programmers_guide.md#sleep-features)'''
          ]
          kind: "spec"
          testpoint: "pad_sleep"
          checks: ["tie low in sleep (assert_PadSleep_TieLowInSleep)"]
          why: '''While the status bit is 1 with mode 0 taken at the entry, the check compares the output of a pad no TAP owns with 0 in the same cycle.'''
          milestone: "V2"
          priority: "2"
          security: false
          state: "open: not reviewed for this top"
        }
        {
          name: REQ_SLP_03b
          desc: '''While its status bit is 1 and its sleep mode is 0, a pad's output enable shall be 1, so the pad drives 0.'''
          source: [
            '''!!MIO_PAD_SLEEP_MODE.OUT'''
            '''[Sleep Features](hw/top_darjeeling/ip_autogen/pinmux/doc/programmers_guide.md#sleep-features)'''
          ]
          kind: "spec"
          testpoint: "pad_sleep"
          checks: ["tie low in sleep (assert_PadSleep_TieLowInSleep)"]
          why: '''While held in mode 0, the check compares the output enable of a pad no TAP owns with 1.'''
          milestone: "V2"
          priority: "2"
          security: false
          state: "open: not reviewed for this top"
        }
        {
          name: REQ_SLP_04a
          desc: '''While its status bit is 1 and its sleep mode is 1, a pad's output shall be 1.'''
          source: [
            '''!!MIO_PAD_SLEEP_MODE.OUT'''
          ]
          kind: "spec"
          testpoint: "pad_sleep"
          checks: ["tie high in sleep (assert_PadSleep_TieHighInSleep)"]
          why: '''While the status bit is 1 with mode 1 taken at the entry, the check compares the output of a pad no TAP owns with 1 in the same cycle.'''
          milestone: "V2"
          priority: "2"
          security: false
          state: "open: not reviewed for this top"
        }
        {
          name: REQ_SLP_04b
          desc: '''While its status bit is 1 and its sleep mode is 1, a pad's output enable shall be 1, so the pad drives 1.'''
          source: [
            '''!!MIO_PAD_SLEEP_MODE.OUT'''
          ]
          kind: "spec"
          testpoint: "pad_sleep"
          checks: ["tie high in sleep (assert_PadSleep_TieHighInSleep)"]
          why: '''While held in mode 1, the check compares the output enable of a pad no TAP owns with 1.'''
          milestone: "V2"
          priority: "2"
          security: false
          state: "open: not reviewed for this top"
        }
        {
          name: REQ_SLP_05a
          desc: '''While its status bit is 1 and its sleep mode is 2, a pad's output enable shall be 0: the pad is high-Z.'''
          source: [
            '''!!MIO_PAD_SLEEP_MODE.OUT'''
          ]
          kind: "spec"
          testpoint: "pad_sleep"
          checks: ["high-Z in sleep (assert_PadSleep_HighZInSleep)"]
          why: '''While the status bit is 1 with mode 2 taken at the entry, the check compares the output enable of a pad no TAP owns with 0 in the same cycle.'''
          milestone: "V2"
          priority: "2"
          security: false
          state: "open: not reviewed for this top"
        }
        {
          name: REQ_SLP_05b
          desc: '''While its status bit is 1 and its sleep mode is 2, a pad's output shall be 0.'''
          source: [
            '''!!MIO_PAD_SLEEP_MODE.OUT'''
          ]
          kind: "spec"
          testpoint: "pad_sleep"
          checks: ["high-Z in sleep (assert_PadSleep_HighZInSleep)"]
          why: '''While held in mode 2, the check compares the output of a pad no TAP owns with 0.'''
          milestone: "V2"
          priority: "2"
          security: false
          state: "open: not reviewed for this top"
        }
        {
          name: REQ_SLP_06a
          desc: '''While its status bit is 1 and its sleep mode is 3, a pad shall keep the output it drove in the last cycle before the bit became 1.'''
          source: [
            '''!!MIO_PAD_SLEEP_MODE.OUT'''
            '''[Retention Logic](hw/top_darjeeling/ip_autogen/pinmux/doc/theory_of_operation.md#retention-logic)'''
          ]
          kind: "spec"
          testpoint: "pad_sleep"
          checks: ["keep holds (assert_PadSleep_KeepHolds)"]
          why: '''While held in mode 3, the check compares a pad's output with its output at the sleep entry that set the bit, if no TAP owned it then or now.'''
          milestone: "V2"
          priority: "2"
          security: false
          state: "open: not reviewed for this top"
        }
        {
          name: REQ_SLP_06b
          desc: '''While its status bit is 1 and its sleep mode is 3, a pad shall keep the output enable it drove in the last cycle before the bit became 1.'''
          source: [
            '''!!MIO_PAD_SLEEP_MODE.OUT'''
            '''[Retention Logic](hw/top_darjeeling/ip_autogen/pinmux/doc/theory_of_operation.md#retention-logic)'''
          ]
          kind: "spec"
          testpoint: "pad_sleep"
          checks: ["keep holds (assert_PadSleep_KeepHolds)"]
          why: '''While held in mode 3, the check compares a pad's output enable with its enable at the sleep entry that set the bit, if no TAP owned it then or now.'''
          milestone: "V2"
          priority: "2"
          security: false
          state: "open: not reviewed for this top"
        }
        {
          name: REQ_SLP_07
          desc: '''Once 1, a status bit shall stay 1 until software writes 0 to it, whatever `sleep_en_i`, the sleep enable and the peripheral do.'''
          source: [
            '''!!MIO_PAD_SLEEP_STATUS.EN'''
            '''[Retention Logic](hw/top_darjeeling/ip_autogen/pinmux/doc/theory_of_operation.md#retention-logic)'''
          ]
          kind: "spec"
          testpoint: "pad_sleep"
          checks: ["bit holds until cleared (assert_PadSleep_BitHoldsUntilCleared)", "clear releases (assert_PadSleep_ClearReleases)"]
          why: '''The first fails a bit at 1 that falls without a software clear; the second requires 0 in the cycle after a clear.'''
          milestone: "V2"
          priority: "2"
          security: false
          state: "open: not reviewed for this top"
        }
        {
          name: REQ_SLP_08
          desc: '''While its status bit is 0, an MIO pad shall drive what its output select names, and a DIO pad the output and output enable of its own peripheral.'''
          source: [
            '''[Retention Logic](hw/top_darjeeling/ip_autogen/pinmux/doc/theory_of_operation.md#retention-logic)'''
            '''[Sleep Features](hw/top_darjeeling/ip_autogen/pinmux/doc/programmers_guide.md#sleep-features)'''
          ]
          kind: "spec"
          testpoint: "sleep_release"
          checks: ["tie 0 drives 0 (assert_PadOutput_Tie0Drives0)", "tie 1 drives 1 (assert_PadOutput_Tie1Drives1)", "select 2 is high-Z (assert_PadOutput_Select2IsHighZ)", "drives selected output (assert_PadOutput_DrivesSelectedOutput)", "no output is high-Z (assert_PadOutput_NoOutputIsHighZ)", "DIO drives its peripheral (assert_PadOutput_DioDrivesItsPeripheral)"]
          why: '''Each holds while the bit is 0.'''
          milestone: "V2"
          priority: "2"
          security: false
          state: "open: not reviewed for this top"
        }
        {
          name: REQ_SLP_09
          desc: '''When sleep entry sets a status bit in the cycle software writes 0 to that bit, the bit shall end 0: software's clear wins.'''
          source: [
            '''!!MIO_PAD_SLEEP_STATUS'''
            '''[Type RW](util/reggen/README.md#type-rw)'''
            '''[Simultaneous SW and HW access](util/reggen/README.md#simultaneous-sw-and-hw-access)'''
          ]
          kind: "spec"
          testpoint: "pad_sleep"
          checks: ["clear wins (assert_PadSleep_ClearWins)"]
          why: '''For a sleep entry with the sleep enable at 1 in the cycle of a software clear of the bit, the check requires the bit to be 0 in the next cycle.'''
          milestone: "V2"
          priority: "2"
          security: false
          state: "open: not reviewed for this top"
        }
        {
          name: REQ_SLP_10a
          desc: '''A write to a pad's sleep mode while its status bit is 1 shall leave the pad as it is.'''
          source: [
            '''[Retention Logic](hw/top_darjeeling/ip_autogen/pinmux/doc/theory_of_operation.md#retention-logic)'''
            '''[Sleep Features](hw/top_darjeeling/ip_autogen/pinmux/doc/programmers_guide.md#sleep-features)'''
          ]
          kind: "spec"
          testpoint: "pad_sleep"
          checks: ["mode write while held (assert_PadSleep_ModeWriteWhileHeld)"]
          why: '''After a sleep mode write while the bit is 1, the check requires the pad to keep the sleep value of the mode taken at the entry.'''
          milestone: "V2"
          priority: "2"
          security: false
          state: "open: not reviewed for this top"
        }
        {
          name: REQ_SLP_10b
          desc: '''After a write to a pad's sleep mode while its status bit is 1, the new mode shall act at the next sleep entry.'''
          source: [
            '''[Retention Logic](hw/top_darjeeling/ip_autogen/pinmux/doc/theory_of_operation.md#retention-logic)'''
            '''[Sleep Features](hw/top_darjeeling/ip_autogen/pinmux/doc/programmers_guide.md#sleep-features)'''
          ]
          kind: "spec"
          testpoint: "pad_sleep"
          checks: ["tie low in sleep (assert_PadSleep_TieLowInSleep)", "tie high in sleep (assert_PadSleep_TieHighInSleep)", "high-Z in sleep (assert_PadSleep_HighZInSleep)", "keep holds (assert_PadSleep_KeepHolds)", "the CSR checker"]
          why: '''Each uses the mode taken at entry; the CSR checker checks the write is kept.'''
          milestone: "V2"
          priority: "2"
          security: false
          state: "open: not reviewed for this top"
        }
      ]
    }
    {
      name: '''Register locks'''
      conditions: [
        '''"lock" is one bit of a `*_REGWEN` register; it locks the registers of the same index, and is open at 1 and closed at 0. The rule that a locked pad's attributes do not change (`REQ_LOCK_03a`, `REQ_LOCK_03b`) holds except on a JTAG pad while a TAP owns it.'''
      ]
      requirements: [
        {
          name: REQ_LOCK_01a
          desc: '''Every lock shall read 1 after reset.'''
          source: [
            '''the register description: the `EN` field of each `*_REGWEN`, e.g. !!MIO_PAD_ATTR_REGWEN.EN `resval: "1"`, on `clk_i` with `rst_ni` ([pinmux.hjson `clocking`](hw/top_darjeeling/ip_autogen/pinmux/data/pinmux.hjson))'''
            '''[Configuration and Register Definition File Format](util/reggen/README.md#configuration-and-register-definition-file-format)'''
          ]
          kind: "spec"
          testpoint: "fpv_csr_rw"
          checks: ["the CSR checker"]
          why: '''After reset the CSR checker expects every lock, bit 31 of `ALERT_TEST` included, at 1 and compares its value and read with it.'''
          milestone: "V2"
          priority: "2"
          security: true
          state: "open: not reviewed for this top"
        }
        {
          name: REQ_LOCK_01b
          desc: '''Once software writes 0 to a lock, the lock shall stay 0 until reset.'''
          source: [
            '''[Configuration and Register Definition File Format](util/reggen/README.md#configuration-and-register-definition-file-format)'''
            '''[Pad Attributes](hw/top_darjeeling/ip_autogen/pinmux/doc/programmers_guide.md#pad-attributes)'''
          ]
          kind: "spec"
          testpoint: "fpv_csr_rw"
          checks: ["the CSR checker"]
          why: '''The CSR checker predicts each lock as `rw0c`: an accepted write of 0 clears it and nothing sets it; a lock that returns to 1 before a reset fails the compare.'''
          milestone: "V2"
          priority: "2"
          security: true
          state: "open: not reviewed for this top"
        }
        {
          name: REQ_LOCK_01c
          desc: '''A write of 1 to a lock that is 0 shall not reopen it.'''
          source: [
            '''the register description: each lock `rw0c`'''
            '''[Configuration and Register Definition File Format](util/reggen/README.md#configuration-and-register-definition-file-format)'''
            '''[Pinmux Configuration](hw/top_darjeeling/ip_autogen/pinmux/doc/programmers_guide.md#pinmux-configuration)'''
          ]
          kind: "spec"
          testpoint: "fpv_csr_rw"
          checks: ["the CSR checker"]
          why: '''The CSR checker predicts each lock as `rw0c`, which keeps a closed lock at 0 over a write of 1; a lock that such a write reopens fails the compare.'''
          milestone: "V2"
          priority: "2"
          security: true
          state: "open: not reviewed for this top"
        }
        {
          name: REQ_LOCK_02
          desc: '''While a lock is 0, a write to a register it locks shall leave that register unchanged.'''
          source: [
            '''!!MIO_PERIPH_INSEL_REGWEN.EN'''
            '''[Configuration and Register Definition File Format](util/reggen/README.md#configuration-and-register-definition-file-format)'''
          ]
          kind: "spec"
          testpoint: "fpv_csr_rw"
          checks: ["locked read-back holds (assert_Regwen_LockedReadBackHolds)", "the CSR checker"]
          why: '''The CSR checker holds a register whose lock reads 0 over writes; _locked read-back holds_ decides the attribute registers.'''
          milestone: "V2"
          priority: "2"
          security: true
          state: "open: not reviewed for this top"
        }
        {
          name: REQ_LOCK_03a
          desc: '''While a pad's attribute lock is 0, its attribute output shall not change.'''
          source: [
            '''!!MIO_PAD_ATTR_REGWEN.EN'''
            '''[Pad Attributes](hw/top_darjeeling/ip_autogen/pinmux/doc/programmers_guide.md#pad-attributes)'''
          ]
          kind: "spec"
          testpoint: "regwen"
          checks: ["locked attribute holds (assert_Regwen_LockedAttributeHolds)"]
          why: '''It holds the pad's attribute output over every cycle its lock is closed, on a pad no TAP owns.'''
          milestone: "V2"
          priority: "2"
          security: true
          state: "open: not reviewed for this top"
        }
        {
          name: REQ_LOCK_03b
          desc: '''While a pad's attribute lock is 0, what its attribute register reads back shall not change.'''
          source: [
            '''!!MIO_PAD_ATTR_REGWEN.EN'''
            '''[Pad Attributes](hw/top_darjeeling/ip_autogen/pinmux/doc/programmers_guide.md#pad-attributes)'''
          ]
          kind: "spec"
          testpoint: "regwen"
          checks: ["locked read-back holds (assert_Regwen_LockedReadBackHolds)"]
          why: '''It holds each pad's read-back over every cycle its lock is closed, an owned JTAG pad included.'''
          milestone: "V2"
          priority: "2"
          security: true
          state: "open: not reviewed for this top"
        }
      ]
    }
    {
      name: '''Register block and bus'''
      conditions: [
        '''a "failed request" is one whose command integrity code does not match, or a write whose data integrity code does not match ([Usage of User Bits](hw/ip/tlul/README.md#usage-of-user-bits)). No row checks the response or the alert of a read whose only mismatch is in its data code. The "in-band reset" is the alert handler's re-initialization. During it, the handler puts a signal integrity error on its ping and acknowledge pairs on purpose ([Employed Solution](hw/top_earlgrey/ip_autogen/alert_handler/doc/theory_of_operation.md#employed-solution)). An "illegal combination of address, size and mask" is an address not aligned to its size, a size above 2, or a mask bit set outside the access. It is also a `PutFullData` mask with a lane of the access at 0.'''
      ]
      requirements: [
        {
          name: REQ_REG_01a
          desc: '''Every register field shall act as its access type says on software reads and writes answered without an error, a write while its lock reads 1 or it has none.'''
          source: [
            '''the register description: each field's `swaccess`, e.g. !!MIO_PAD_SLEEP_STATUS `swaccess: "rw0c"`'''
            '''[Configuration and Register Definition File Format](util/reggen/README.md#configuration-and-register-definition-file-format)'''
          ]
          kind: "spec"
          testpoint: "fpv_csr_rw"
          checks: ["read-back changes only on a write (assert_PadAttr_ReadBackChangesOnlyOnAWrite)", "the CSR checker"]
          why: '''The CSR checker predicts each field from its access type, the pad_attr check the attribute registers.'''
          milestone: "V2"
          priority: "2"
          security: true
          state: "open: not reviewed for this top"
        }
        {
          name: REQ_REG_01b
          desc: '''Every register field shall read its register description reset value after reset.'''
          source: [
            '''the register description: each field's `resval`, e.g. !!MIO_PAD_SLEEP_STATUS.EN `resval: "0"`'''
            '''[Configuration and Register Definition File Format](util/reggen/README.md#configuration-and-register-definition-file-format)'''
          ]
          kind: "spec"
          testpoint: "fpv_csr_rw"
          checks: ["the CSR checker"]
          why: '''After reset the CSR checker expects each field at its reset value; _reset attributes_ decides the attribute registers.'''
          milestone: "V2"
          priority: "2"
          security: true
          state: "open: not reviewed for this top"
        }
        {
          name: REQ_BUS_01a
          desc: '''The pinmux shall answer every request with one response, and only one.'''
          source: [
            '''TileLink 1.9.3 p. 39: "Receipt of request messages must result in the eventual receipt of a response message by the requestor."; p. 30: "it is illegal to receive a response without receiving the request."; p. 46: "In TL-UL, every message fits within a single beat"'''
          ]
          kind: "spec"
          testpoint: "bus"
          checks: ["device rules (assert_Bus_DeviceRules)"]
          why: '''The TL-UL ABVIP's device rules match each response on the pinmux's port to one open request.'''
          milestone: "V2"
          priority: "2"
          security: true
          state: "open: not reviewed for this top"
        }
        {
          name: REQ_BUS_01b
          desc: '''The pinmux shall answer every request by the TL-UL rules with a response that carries the request's source ID.'''
          source: [
            '''[Source ID requirements for device elements](hw/ip/tlul/README.md#source-id-requirements-for-device-elements)'''
          ]
          kind: "spec"
          testpoint: "bus"
          checks: ["device rules (assert_Bus_DeviceRules)"]
          why: '''The TL-UL ABVIP's device rules compare each response's `d_source` with its request's `a_source`.'''
          milestone: "V2"
          priority: "2"
          security: true
          state: "open: not reviewed for this top"
        }
        {
          name: REQ_BUS_01c
          desc: '''Only a failed request, a case of `REQ_BUS_10a` to `REQ_BUS_10d` or one to an address no register maps shall get an error.'''
          source: [
            '''[Explicit Error Cases](hw/ip/tlul/README.md#explicit-error-cases)'''
            '''[Error responses](util/reggen/README.md#error-responses)'''
          ]
          kind: "spec"
          testpoint: "bus"
          checks: ["errors as the register checker predicts", "the CSR checker"]
          why: '''The CSR checker's error checks require `d_error` 1 on a request not failed exactly for a listed cause.'''
          milestone: "V2"
          priority: "2"
          security: true
          state: "open: not reviewed for this top"
        }
        {
          name: REQ_BUS_02a
          desc: '''Every response shall carry the response integrity code over its op code, size and error.'''
          source: [
            '''[Usage of User Bits](hw/ip/tlul/README.md#usage-of-user-bits)'''
            '''[pinmux.hjson `countermeasures` BUS.INTEGRITY](hw/top_darjeeling/ip_autogen/pinmux/data/pinmux.hjson)'''
          ]
          kind: "spec"
          testpoint: "bus"
          checks: ["response codes correct (assert_Bus_ResponseCodesCorrect)"]
          why: '''It recomputes the response code from each response's opcode, size and error with the shared encoder and compares it with the code sent.'''
          milestone: "V2"
          priority: "2"
          security: true
          state: "open: not reviewed for this top"
        }
        {
          name: REQ_BUS_02b
          desc: '''Every response shall carry the data integrity code over its data.'''
          source: [
            '''[Usage of User Bits](hw/ip/tlul/README.md#usage-of-user-bits)'''
            '''[pinmux.hjson `countermeasures` BUS.INTEGRITY](hw/top_darjeeling/ip_autogen/pinmux/data/pinmux.hjson)'''
          ]
          kind: "spec"
          testpoint: "bus"
          checks: ["response codes correct (assert_Bus_ResponseCodesCorrect)"]
          why: '''It recomputes the data code over each response's data with the shared encoder and compares it with the code sent.'''
          milestone: "V2"
          priority: "2"
          security: true
          state: "open: not reviewed for this top"
        }
        {
          name: REQ_BUS_03
          desc: '''A failed request shall get an error response.'''
          source: [
            '''[Usage of User Bits](hw/ip/tlul/README.md#usage-of-user-bits)'''
            '''[cip_base_vseq](hw/dv/sv/cip_lib/README.md#cip_base_vseq)'''
          ]
          kind: "RTL"
          testpoint: "bus"
          checks: ["failed request errors (assert_Bus_FailedRequestErrors)"]
          why: '''It requires `d_error` 1 on the response to every failed request.'''
          milestone: "V2"
          priority: "2"
          security: true
          state: "open: not reviewed for this top"
        }
        {
          name: REQ_BUS_04
          desc: '''A failed write shall change no register.'''
          source: [
            '''[Usage of User Bits](hw/ip/tlul/README.md#usage-of-user-bits)'''
          ]
          kind: "RTL"
          testpoint: "bus"
          checks: ["failed write changes nothing (assert_Bus_FailedWriteChangesNothing)"]
          why: '''It holds every register over a failed write, but for an AON field taking an earlier write not yet landed.'''
          milestone: "V2"
          priority: "2"
          security: true
          state: "open: not reviewed for this top"
        }
        {
          name: REQ_BUS_05
          desc: '''Outside the alert handler's in-band reset, a failed request shall raise the fatal alert `fatal_fault`.'''
          source: [
            '''[pinmux.hjson `alert_list` fatal_fault](hw/top_darjeeling/ip_autogen/pinmux/data/pinmux.hjson)'''
            '''[Employed Solution](hw/top_earlgrey/ip_autogen/alert_handler/doc/theory_of_operation.md#employed-solution)'''
          ]
          kind: "spec"
          testpoint: "alert"
          checks: ["failed request alerts (assert_Alert_FailedRequestAlerts)"]
          why: '''It requires an alert event on `alert_tx_o` within 40 cycles of every failed request.'''
          milestone: "V2S"
          priority: "2"
          security: true
          state: "open: not reviewed for this top"
        }
        {
          name: REQ_BUS_06
          desc: '''Outside the alert handler's in-band reset, once raised, the fatal alert shall be sent again and again until reset.'''
          source: [
            '''[Alerts per Module](doc/contributing/hw/comportability/README.md#alerts-per-module)'''
            '''[Employed Solution](hw/top_earlgrey/ip_autogen/alert_handler/doc/theory_of_operation.md#employed-solution)'''
          ]
          kind: "spec"
          testpoint: "alert"
          checks: ["fatal alert repeats (assert_Alert_FatalAlertRepeats)"]
          why: '''After a failed request it requires an alert event within 40 cycles of every cycle, until reset.'''
          milestone: "V2S"
          priority: "2"
          security: true
          state: "open: not reviewed for this top"
        }
        {
          name: REQ_BUS_07
          desc: '''Outside the alert handler's in-band reset, a write of 1 to `ALERT_TEST` bit 0 not answered with an error, while its bit 31 is 1, shall send one alert event.'''
          source: [
            '''The register page says of bit 0: "Write 1 to trigger one alert event of this kind." (!!ALERT_TEST)'''
            '''[Test Alert Register Creation](doc/contributing/hw/comportability/README.md#test-alert-register-creation)'''
            '''[Employed Solution](hw/top_earlgrey/ip_autogen/alert_handler/doc/theory_of_operation.md#employed-solution)'''
          ]
          kind: "spec"
          testpoint: "alert"
          checks: ["test sends an event (assert_Alert_TestSendsAnEvent)", "no alert without a cause (assert_Alert_NoAlertWithoutACause)"]
          why: '''Each alert test needs an event within 40 cycles, and each event uses up one test credit, so one test gives one event.'''
          milestone: "V2S"
          priority: "2"
          security: true
          state: "open: not reviewed for this top"
        }
        {
          name: REQ_BUS_08
          desc: '''Outside the alert handler's in-band reset, while `ALERT_TEST` bit 31 is 0, a write to its bit 0 that is not a failed request shall send no alert.'''
          source: [
            '''The register page says of bit 31: "Write 0 to disable alert testing until the next reset." (!!ALERT_TEST)'''
            '''[Employed Solution](hw/top_earlgrey/ip_autogen/alert_handler/doc/theory_of_operation.md#employed-solution)'''
          ]
          kind: "spec"
          testpoint: "alert"
          checks: ["no alert without a cause (assert_Alert_NoAlertWithoutACause)"]
          why: '''A write of bit 0 while bit 31 of `ALERT_TEST` is 0 sets no test credit, so an alert event with no other cause fails it.'''
          milestone: "V2S"
          priority: "2"
          security: true
          state: "open: not reviewed for this top"
        }
        {
          name: REQ_BUS_09
          desc: '''Outside the in-band reset and apart from ping answers, the fatal alert shall be sent only after a failed request or an alert test.'''
          source: [
            '''[pinmux.hjson `alert_list` fatal_fault](hw/top_darjeeling/ip_autogen/pinmux/data/pinmux.hjson)'''
            '''[Employed Solution](hw/top_earlgrey/ip_autogen/alert_handler/doc/theory_of_operation.md#employed-solution)'''
          ]
          kind: "spec"
          testpoint: "alert"
          checks: ["no alert without a cause (assert_Alert_NoAlertWithoutACause)"]
          why: '''It allows an alert event only after a failed request or against a ping or test credit, one per event.'''
          milestone: "V2S"
          priority: "2"
          security: true
          state: "open: not reviewed for this top"
        }
        {
          name: REQ_BUS_10a
          desc: '''A request with an *undefined opcode* shall get an error response.'''
          source: [
            '''[Usage of Opcode, Size and Mask](hw/ip/tlul/README.md#usage-of-opcode-size-and-mask)'''
            '''[Error responses](util/reggen/README.md#error-responses)'''
          ]
          kind: "spec"
          testpoint: "bus"
          checks: ["errors as the register checker predicts", "the CSR checker"]
          why: '''The CSR checker's error checks require `d_error` 1 on an undefined opcode, which the run leaves free.'''
          milestone: "V2"
          priority: "2"
          security: true
          state: "open: not reviewed for this top"
        }
        {
          name: REQ_BUS_10b
          desc: '''A request with an *illegal combination of address, size and mask*, as the Conditions above defines it, shall get an error response.'''
          source: [
            '''[Explicit Error Cases](hw/ip/tlul/README.md#explicit-error-cases)'''
            '''TileLink 1.9.3 p. 51: "a_address must be aligned to a_size."'''
          ]
          kind: "spec"
          testpoint: "bus"
          checks: ["errors as the register checker predicts", "the CSR checker"]
          why: '''The CSR checker's error checks require `d_error` 1 on an illegal fit, masks kept contiguous in the run.'''
          milestone: "V2"
          priority: "2"
          security: true
          state: "open: not reviewed for this top"
        }
        {
          name: REQ_BUS_10c
          desc: '''A *write of 8 or 16 bits to an address not aligned to a word* shall get an error response.'''
          source: [
            '''[Error responses](util/reggen/README.md#error-responses)'''
            '''[Explicit Error Cases](hw/ip/tlul/README.md#explicit-error-cases)'''
          ]
          kind: "spec"
          testpoint: "bus"
          checks: ["errors as the register checker predicts", "the CSR checker"]
          why: '''The CSR checker's error checks require `d_error` 1 on an 8 or 16 bit write not aligned to a word.'''
          milestone: "V2"
          priority: "2"
          security: true
          state: "open: not reviewed for this top"
        }
        {
          name: REQ_BUS_10d
          desc: '''A *write narrower than its register*, whose width the location of its fields sets, shall get an error response.'''
          source: [
            '''[Error responses](util/reggen/README.md#error-responses)'''
          ]
          kind: "spec"
          testpoint: "bus"
          checks: ["errors as the register checker predicts", "the CSR checker"]
          why: '''The CSR checker's error checks require `d_error` 1 on a write narrower than its register.'''
          milestone: "V2"
          priority: "2"
          security: true
          state: "open: not reviewed for this top"
        }
        {
          name: REQ_BUS_10e
          desc: '''A request to an *address no register maps*, within the address bits the register block decodes, shall get an error response.'''
          source: [
            '''[Explicit Error Cases](hw/ip/tlul/README.md#explicit-error-cases)'''
            '''[Error responses](util/reggen/README.md#error-responses)'''
          ]
          kind: "spec"
          testpoint: "bus"
          checks: ["errors as the register checker predicts", "the CSR checker"]
          why: '''The CSR checker's error checks require `d_error` 1 on an address no register maps.'''
          milestone: "V2"
          priority: "2"
          security: true
          state: "open: not reviewed for this top"
        }
        {
          name: REQ_BUS_11
          desc: '''A write answered with an error for any reason other than a failed integrity check shall change no register.'''
          source: [
            '''[cip_base_vseq](hw/dv/sv/cip_lib/README.md#cip_base_vseq)'''
            '''[Error responses](util/reggen/README.md#error-responses)'''
          ]
          kind: "spec"
          testpoint: "bus"
          checks: ["error write changes nothing", "the CSR checker"]
          why: '''An error write is no accepted write, so the CSR checker and the attribute and AON no-write checks hold every register.'''
          milestone: "V2"
          priority: "2"
          security: true
          state: "open: not reviewed for this top"
        }
      ]
    }
    {
      name: '''Wakeup detectors'''
      conditions: [
        '''`w` is a detector (0 to 7); a cycle is a `clk_aon_i` cycle; the watched signal and the forwarded value are defined in the Terms.'''
        '''Register values are those the AON logic holds once a write has crossed. The rows hold with the mode unchanged while enabled, the other fields free to change.'''
        '''They hold whatever `sleep_en_i`, `clk_i` (stopped included) and the scan mode do, except scan mode True while the detector watches a scan clock pad.'''
        '''They are checked from the filter's fourth sample after `rst_aon_ni`. The timed rows (`REQ_WKUP_09a` to `REQ_WKUP_10b`) hold for `CNT_TH` 1 and above.'''
      ]
      requirements: [
        {
          name: REQ_WKUP_01
          desc: '''With `MIODIO` 0, the watched signal shall be MIO pad `PADSEL` - 2 for `PADSEL` 2 to 13, and the constant 0 or 1 for `PADSEL` 0 or 1.'''
          source: [
            '''!!MIO_PERIPH_INSEL.IN'''
            '''!!WKUP_DETECTOR.MIODIO'''
            '''!!WKUP_DETECTOR_PADSEL.SEL'''
            '''[Retention and Wakeup Features](hw/top_darjeeling/ip_autogen/pinmux/doc/theory_of_operation.md#retention-and-wakeup-features)'''
            '''[Wakeup Detectors](hw/top_darjeeling/ip_autogen/pinmux/doc/theory_of_operation.md#wakeup-detectors)'''
            '''[top_darjeeling_pinmux.ipconfig.hjson `n_mio_pads`](hw/top_darjeeling/ip_autogen/pinmux/data/top_darjeeling_pinmux.ipconfig.hjson)'''
          ]
          kind: "spec"
          testpoint: "wakeup"
          checks: ["edge sets cause (assert_Wakeup_EdgeSetsCause)", "timed high sets cause (assert_Wakeup_TimedHighSetsCause)", "timed low sets cause (assert_Wakeup_TimedLowSetsCause)", "no false cause (assert_Wakeup_NoFalseCause)"]
          why: '''The checks watch the MIO pad or constant the select names.'''
          milestone: "V2"
          priority: "1"
          security: false
          state: "open: not reviewed for this top"
        }
        {
          name: REQ_WKUP_02
          desc: '''With `MIODIO` 1, the watched signal shall be DIO pad `PADSEL` for `PADSEL` 0 to 72.'''
          source: [
            '''!!WKUP_DETECTOR.MIODIO'''
            '''!!WKUP_DETECTOR_PADSEL.SEL'''
            '''[MIO and DIO Signal Categories](hw/top_darjeeling/ip_autogen/pinmux/doc/theory_of_operation.md#mio-and-dio-signal-categories)'''
            '''[top_darjeeling_pinmux.ipconfig.hjson `n_dio_pads`](hw/top_darjeeling/ip_autogen/pinmux/data/top_darjeeling_pinmux.ipconfig.hjson)'''
          ]
          kind: "spec"
          testpoint: "wakeup"
          checks: ["edge sets cause (assert_Wakeup_EdgeSetsCause)", "no false cause (assert_Wakeup_NoFalseCause)"]
          why: '''The checks watch the forwarded value of the DIO pad the select names.'''
          milestone: "V2"
          priority: "1"
          security: false
          state: "open: not reviewed for this top"
        }
        {
          name: REQ_WKUP_03
          desc: '''A `PADSEL` that names no pad (14 to 127 with `MIODIO` 0, 73 to 127 with `MIODIO` 1) shall give the watched signal 0.'''
          source: [
            '''!!WKUP_DETECTOR_PADSEL.SEL'''
            '''[top_darjeeling_pinmux.ipconfig.hjson `n_mio_pads`, `n_dio_pads`](hw/top_darjeeling/ip_autogen/pinmux/data/top_darjeeling_pinmux.ipconfig.hjson)'''
          ]
          kind: "spec"
          testpoint: "wakeup"
          checks: ["timed low sets cause (assert_Wakeup_TimedLowSetsCause)", "no false cause (assert_Wakeup_NoFalseCause)"]
          why: '''The checks watch 0 on a select that names no pad, so mode 4 must fire and no edge may set the bit.'''
          milestone: "V2"
          priority: "1"
          security: false
          state: "open: not reviewed for this top"
        }
        {
          name: REQ_WKUP_04
          desc: '''With `FILTER` 0, the forwarded value shall be the watched signal as sampled at each `clk_aon_i` edge.'''
          source: [
            '''[Wakeup Detectors](hw/top_darjeeling/ip_autogen/pinmux/doc/theory_of_operation.md#wakeup-detectors)'''
          ]
          kind: "spec"
          testpoint: "wakeup"
          checks: ["edge sets cause (assert_Wakeup_EdgeSetsCause)", "no false cause (assert_Wakeup_NoFalseCause)"]
          why: '''With `FILTER` 0 the forwarded value the checks watch is the pad as sampled, up to 4 cycles late.'''
          milestone: "V2"
          priority: "1"
          security: false
          state: "open: not reviewed for this top"
        }
        {
          name: REQ_WKUP_05
          desc: '''With `FILTER` 1, the forwarded value shall take a new value only once 4 samples in a row have had it.'''
          source: [
            '''!!WKUP_DETECTOR.FILTER'''
          ]
          kind: "spec"
          testpoint: "wakeup"
          checks: ["edge sets cause (assert_Wakeup_EdgeSetsCause)", "no false cause (assert_Wakeup_NoFalseCause)"]
          why: '''A level held for 4 samples is an edge of the forwarded value, and a 3-sample glitch is none.'''
          milestone: "V2"
          priority: "1"
          security: false
          state: "open: not reviewed for this top"
        }
        {
          name: REQ_WKUP_06a
          desc: '''An enabled detector in mode 0 (Posedge) shall detect every rise of the forwarded value.'''
          source: [
            '''!!WKUP_DETECTOR.MODE'''
            '''[Wakeup Detectors](hw/top_darjeeling/ip_autogen/pinmux/doc/theory_of_operation.md#wakeup-detectors)'''
          ]
          kind: "spec"
          testpoint: "wakeup"
          checks: ["posedge sets cause (assert_Wakeup_PosedgeSetsCause)"]
          why: '''It wants a hardware write of 1 within 8 cycles of each rise of the forwarded value, a one-sample pulse included, with `EN` 1 then and 4 cycles on.'''
          milestone: "V2"
          priority: "1"
          security: false
          state: "open: not reviewed for this top"
        }
        {
          name: REQ_WKUP_06b
          desc: '''An enabled detector in mode 0 (Posedge) shall detect only at a rise of the forwarded value.'''
          source: [
            '''!!WKUP_DETECTOR.MODE'''
            '''[Wakeup Detectors](hw/top_darjeeling/ip_autogen/pinmux/doc/theory_of_operation.md#wakeup-detectors)'''
          ]
          kind: "spec"
          testpoint: "wakeup"
          checks: ["no false cause (assert_Wakeup_NoFalseCause)"]
          why: '''In mode 0 it refuses a hardware write of 1 to a cause bit at 0 that no rise of the forwarded value, seen up to 4 cycles late with `EN` 1, answers.'''
          milestone: "V2"
          priority: "1"
          security: false
          state: "open: not reviewed for this top"
        }
        {
          name: REQ_WKUP_07a
          desc: '''An enabled detector in mode 1 (Negedge) shall detect every fall of the forwarded value.'''
          source: [
            '''!!WKUP_DETECTOR.MODE'''
          ]
          kind: "spec"
          testpoint: "wakeup"
          checks: ["negedge sets cause (assert_Wakeup_NegedgeSetsCause)"]
          why: '''It wants a hardware write of 1 to bit `w` within 8 cycles of each fall of the forwarded value with `EN` 1 then and for 4 more cycles.'''
          milestone: "V2"
          priority: "1"
          security: false
          state: "open: not reviewed for this top"
        }
        {
          name: REQ_WKUP_07b
          desc: '''An enabled detector in mode 1 (Negedge) shall detect only at a fall of the forwarded value.'''
          source: [
            '''!!WKUP_DETECTOR.MODE'''
          ]
          kind: "spec"
          testpoint: "wakeup"
          checks: ["no false cause (assert_Wakeup_NoFalseCause)"]
          why: '''In mode 1 it refuses a hardware write of 1 to a cause bit at 0 that no fall of the forwarded value answers: a detector that fires on a rise fails it.'''
          milestone: "V2"
          priority: "1"
          security: false
          state: "open: not reviewed for this top"
        }
        {
          name: REQ_WKUP_08a
          desc: '''An enabled detector in mode 2 (Edge) shall detect every change of the forwarded value.'''
          source: [
            '''!!WKUP_DETECTOR.MODE'''
          ]
          kind: "spec"
          testpoint: "wakeup"
          checks: ["edge sets cause (assert_Wakeup_EdgeSetsCause)"]
          why: '''It wants a hardware write of 1 to bit `w` within 8 cycles of each rise and each fall of the forwarded value with `EN` 1 then and for 4 more cycles.'''
          milestone: "V2"
          priority: "1"
          security: false
          state: "open: not reviewed for this top"
        }
        {
          name: REQ_WKUP_08b
          desc: '''An enabled detector in mode 2 (Edge) shall detect only at a change of the forwarded value.'''
          source: [
            '''!!WKUP_DETECTOR.MODE'''
          ]
          kind: "spec"
          testpoint: "wakeup"
          checks: ["no false cause (assert_Wakeup_NoFalseCause)"]
          why: '''In mode 2 it refuses a hardware write of 1 to a cause bit at 0 that no rise or fall of the forwarded value answers.'''
          milestone: "V2"
          priority: "1"
          security: false
          state: "open: not reviewed for this top"
        }
        {
          name: REQ_WKUP_09a
          desc: '''An enabled detector in mode 3 (TimedHigh) shall detect when the forwarded value has been 1 for `CNT_TH` cycles in a row.'''
          source: [
            '''!!WKUP_DETECTOR.MODE'''
            '''!!WKUP_DETECTOR_CNT_TH.TH'''
            '''[Wakeup Detectors](hw/top_darjeeling/ip_autogen/pinmux/doc/theory_of_operation.md#wakeup-detectors)'''
            '''[top_darjeeling_pinmux.ipconfig.hjson `wkup_cnt_width`](hw/top_darjeeling/ip_autogen/pinmux/data/top_darjeeling_pinmux.ipconfig.hjson)'''
          ]
          kind: "spec"
          testpoint: "wakeup"
          checks: ["timed high sets cause (assert_Wakeup_TimedHighSetsCause)"]
          why: '''It wants the cause bit set within 8 cycles of the forwarded value 1 for `CNT_TH` + 1 cycles in a row with `EN` 1, the later count allowed.'''
          milestone: "V2"
          priority: "1"
          security: false
          state: "open: not reviewed for this top"
        }
        {
          name: REQ_WKUP_09b
          desc: '''An enabled detector in mode 3 (TimedHigh) shall *never detect* while the forwarded value has been 1 for fewer than `CNT_TH` cycles in a row.'''
          source: [
            '''!!WKUP_DETECTOR.MODE'''
            '''[top_darjeeling_pinmux.ipconfig.hjson `wkup_cnt_width`](hw/top_darjeeling/ip_autogen/pinmux/data/top_darjeeling_pinmux.ipconfig.hjson)'''
          ]
          kind: "spec"
          testpoint: "wakeup"
          checks: ["no false cause (assert_Wakeup_NoFalseCause)"]
          why: '''In mode 3 it refuses a set of the cause bit while the forwarded value has been 1 for fewer than `CNT_TH` cycles in a row with `EN` 1.'''
          milestone: "V2"
          priority: "1"
          security: false
          state: "open: not reviewed for this top"
        }
        {
          name: REQ_WKUP_10a
          desc: '''An enabled detector in mode 4 (TimedLow) shall detect when the forwarded value has been 0 for `CNT_TH` cycles in a row.'''
          source: [
            '''!!WKUP_DETECTOR.MODE'''
            '''!!WKUP_DETECTOR_CNT_TH.TH'''
            '''[Wakeup Detectors](hw/top_darjeeling/ip_autogen/pinmux/doc/theory_of_operation.md#wakeup-detectors)'''
            '''[top_darjeeling_pinmux.ipconfig.hjson `wkup_cnt_width`](hw/top_darjeeling/ip_autogen/pinmux/data/top_darjeeling_pinmux.ipconfig.hjson)'''
          ]
          kind: "spec"
          testpoint: "wakeup"
          checks: ["timed low sets cause (assert_Wakeup_TimedLowSetsCause)"]
          why: '''It wants the cause bit set within 8 cycles of the forwarded value 0 for `CNT_TH` + 1 cycles in a row with `EN` 1, the later count allowed.'''
          milestone: "V2"
          priority: "1"
          security: false
          state: "open: not reviewed for this top"
        }
        {
          name: REQ_WKUP_10b
          desc: '''An enabled detector in mode 4 (TimedLow) shall *never detect* while the forwarded value has been 0 for fewer than `CNT_TH` cycles in a row.'''
          source: [
            '''!!WKUP_DETECTOR.MODE'''
            '''[top_darjeeling_pinmux.ipconfig.hjson `wkup_cnt_width`](hw/top_darjeeling/ip_autogen/pinmux/data/top_darjeeling_pinmux.ipconfig.hjson)'''
          ]
          kind: "spec"
          testpoint: "wakeup"
          checks: ["no false cause (assert_Wakeup_NoFalseCause)"]
          why: '''In mode 4 it refuses a set of the cause bit while the forwarded value has been 0 for fewer than `CNT_TH` cycles in a row with `EN` 1.'''
          milestone: "V2"
          priority: "1"
          security: false
          state: "open: not reviewed for this top"
        }
        {
          name: REQ_WKUP_11
          desc: '''An enabled detector in mode 5, 6 or 7 shall detect exactly the rises of the forwarded value, as in mode 0 (Posedge).'''
          source: [
            '''!!WKUP_DETECTOR.MODE'''
          ]
          kind: "spec"
          testpoint: "wakeup"
          checks: ["posedge sets cause (assert_Wakeup_PosedgeSetsCause)", "no false cause (assert_Wakeup_NoFalseCause)"]
          why: '''Both checks read `MODE` 5, 6 and 7 as mode 0.'''
          milestone: "V2"
          priority: "1"
          security: false
          state: "open: not reviewed for this top"
        }
        {
          name: REQ_WKUP_12
          desc: '''A detector whose enable is 0 shall detect nothing.'''
          source: [
            '''!!WKUP_DETECTOR_EN.EN'''
          ]
          kind: "spec"
          testpoint: "wakeup"
          checks: ["no false cause (assert_Wakeup_NoFalseCause)"]
          why: '''It refuses a hardware write of 1 to a cause bit at 0 that no pattern with `EN` 1 answers; an edge within 4 cycles of an enable change may set it or not.'''
          milestone: "V2"
          priority: "1"
          security: false
          state: "open: not reviewed for this top"
        }
        {
          name: REQ_WKUP_13a
          desc: '''The sampling shall run while the detector is disabled, so that enabling the detector does not restart it.'''
          source: [
            '''None: the theory of operation and the register description are silent'''
          ]
          kind: "RTL"
          testpoint: "wakeup"
          checks: ["no false cause (assert_Wakeup_NoFalseCause)", "posedge sets cause (assert_Wakeup_PosedgeSetsCause)"]
          why: '''The checks sample the pad whatever `EN` is: a pad at 1 before the enable is no rise, a rise just after it is one.'''
          milestone: "V2"
          priority: "1"
          security: false
          state: "open: not reviewed for this top"
        }
        {
          name: REQ_WKUP_13b
          desc: '''The filter shall run while the detector is disabled, so that enabling the detector does not restart it.'''
          source: [
            '''None: the theory of operation and the register description are silent'''
          ]
          kind: "RTL"
          testpoint: "wakeup"
          checks: ["no false cause (assert_Wakeup_NoFalseCause)", "posedge sets cause (assert_Wakeup_PosedgeSetsCause)"]
          why: '''The checks' filter runs whatever `EN` is: a rise whose 4 samples span the enable counts, a pad at 1 before it does not.'''
          milestone: "V2"
          priority: "1"
          security: false
          state: "open: not reviewed for this top"
        }
        {
          name: REQ_WKUP_14
          desc: '''When an enabled detector detects, bit `w` of `WKUP_CAUSE` shall become 1.'''
          source: [
            '''[Wakeup Detectors](hw/top_darjeeling/ip_autogen/pinmux/doc/theory_of_operation.md#wakeup-detectors)'''
            '''!!WKUP_CAUSE.CAUSE'''
            '''[Wakeup Features](hw/top_darjeeling/ip_autogen/pinmux/doc/programmers_guide.md#wakeup-features)'''
            '''[top_darjeeling_pinmux.ipconfig.hjson `n_wkup_detect`](hw/top_darjeeling/ip_autogen/pinmux/data/top_darjeeling_pinmux.ipconfig.hjson)'''
          ]
          kind: "spec"
          testpoint: "wakeup"
          checks: ["posedge sets cause (assert_Wakeup_PosedgeSetsCause)", "negedge sets cause (assert_Wakeup_NegedgeSetsCause)", "edge sets cause (assert_Wakeup_EdgeSetsCause)", "timed high sets cause (assert_Wakeup_TimedHighSetsCause)", "timed low sets cause (assert_Wakeup_TimedLowSetsCause)", "set lands (assert_Wakeup_SetLands)"]
          why: '''Set within 8 cycles; bit 1 a cycle later.'''
          milestone: "V2"
          priority: "1"
          security: false
          state: "open: not reviewed for this top"
        }
        {
          name: REQ_WKUP_15
          desc: '''Bit `w` of `WKUP_CAUSE` shall become 1 only when detector `w` detects.'''
          source: [
            '''!!WKUP_CAUSE.CAUSE'''
            '''[top_darjeeling_pinmux.ipconfig.hjson `n_wkup_detect`](hw/top_darjeeling/ip_autogen/pinmux/data/top_darjeeling_pinmux.ipconfig.hjson)'''
          ]
          kind: "spec"
          testpoint: "wakeup"
          checks: ["no false cause (assert_Wakeup_NoFalseCause)", "cause rises only on a set (assert_Wakeup_CauseRisesOnlyOnASet)"]
          why: '''Only a pattern of detector `w` may set bit `w`, and bit `w` rises only on a set.'''
          milestone: "V2"
          priority: "1"
          security: false
          state: "open: not reviewed for this top"
        }
        {
          name: REQ_WKUP_16
          desc: '''Once 1, a cause bit shall stay 1 until software's clear of it lands, whatever the detector, its enable and the pad do.'''
          source: [
            '''!!WKUP_CAUSE'''
            '''!!WKUP_CAUSE.CAUSE'''
            '''[Wakeup Features](hw/top_darjeeling/ip_autogen/pinmux/doc/programmers_guide.md#wakeup-features)'''
            '''[Wakeup Recording](hw/top_darjeeling/ip_autogen/pwrmgr/doc/theory_of_operation.md#wakeup-recording)'''
          ]
          kind: "spec"
          testpoint: "wakeup_cause"
          checks: ["cause holds until cleared (assert_WakeupCause_CauseHoldsUntilCleared)", "hardware only sets cause (assert_WakeupCause_HardwareOnlySetsCause)"]
          why: '''The bit falls only on a landed clear or at `rst_aon_ni`; hardware writes it 0 only as a clear lands.'''
          milestone: "V2"
          priority: "2"
          security: false
          state: "open: not reviewed for this top"
        }
        {
          name: REQ_WKUP_17
          desc: '''When a detection sets a cause bit in the cycle software's clear of it lands, the bit shall end 0: software's clear wins.'''
          source: [
            '''!!WKUP_CAUSE'''
            '''[Type RW](util/reggen/README.md#type-rw)'''
            '''[Simultaneous SW and HW access](util/reggen/README.md#simultaneous-sw-and-hw-access)'''
          ]
          kind: "spec"
          testpoint: "wakeup_cause"
          checks: ["set and clear together (assert_WakeupCause_SetAndClearTogether)"]
          why: '''When a hardware write of 1 to a cause bit meets a landing clear of that bit, it wants the bit 0 in the next cycle.'''
          milestone: "V2"
          priority: "2"
          security: false
          state: "open: not reviewed for this top"
        }
        {
          name: REQ_WKUP_18a
          desc: '''`pin_wkup_req_o` shall be 1 while at least one cause bit is 1.'''
          source: [
            '''[Inter-Module Signals](hw/top_darjeeling/ip_autogen/pinmux/doc/interfaces.md#inter-module-signals)'''
            '''[Wakeup Detectors](hw/top_darjeeling/ip_autogen/pinmux/doc/theory_of_operation.md#wakeup-detectors)'''
            '''[Wakeup Recording](hw/top_darjeeling/ip_autogen/pwrmgr/doc/theory_of_operation.md#wakeup-recording)'''
            '''[top_darjeeling_pinmux.ipconfig.hjson `n_wkup_detect`](hw/top_darjeeling/ip_autogen/pinmux/data/top_darjeeling_pinmux.ipconfig.hjson)'''
          ]
          kind: "spec"
          testpoint: "wakeup_cause"
          checks: ["request follows cause (assert_WakeupCause_RequestFollowsCause)"]
          why: '''It wants `pin_wkup_req_o` 1 within 2 cycles of any cause bit rising, and while any has held 1 for 3 cycles in a row.'''
          milestone: "V2"
          priority: "2"
          security: false
          state: "open: not reviewed for this top"
        }
        {
          name: REQ_WKUP_18b
          desc: '''`pin_wkup_req_o` shall be 0 while every cause bit is 0.'''
          source: [
            '''[Inter-Module Signals](hw/top_darjeeling/ip_autogen/pinmux/doc/interfaces.md#inter-module-signals)'''
            '''[Wakeup Detectors](hw/top_darjeeling/ip_autogen/pinmux/doc/theory_of_operation.md#wakeup-detectors)'''
            '''[Wakeup Recording](hw/top_darjeeling/ip_autogen/pwrmgr/doc/theory_of_operation.md#wakeup-recording)'''
            '''[top_darjeeling_pinmux.ipconfig.hjson `n_wkup_detect`](hw/top_darjeeling/ip_autogen/pinmux/data/top_darjeeling_pinmux.ipconfig.hjson)'''
          ]
          kind: "spec"
          testpoint: "wakeup_cause"
          checks: ["no request without cause (assert_WakeupCause_NoRequestWithoutCause)"]
          why: '''It wants `pin_wkup_req_o` 0 once every cause bit has been 0 for 3 cycles in a row.'''
          milestone: "V2"
          priority: "2"
          security: false
          state: "open: not reviewed for this top"
        }
        {
          name: REQ_WKUP_19a
          desc: '''A write to a detector's enable shall reach the AON logic within a bounded time.'''
          source: [
            '''!!WKUP_DETECTOR_EN'''
            '''!!WKUP_DETECTOR'''
            '''!!WKUP_DETECTOR_CNT_TH'''
            '''!!WKUP_CAUSE'''
            '''[Wakeup Features](hw/top_darjeeling/ip_autogen/pinmux/doc/programmers_guide.md#wakeup-features)'''
          ]
          kind: "spec"
          testpoint: "wakeup_sync"
          checks: ["write lands (assert_WakeupSync_WriteLands)", "no change without a write (assert_WakeupSync_NoChangeWithoutAWrite)"]
          why: '''For `EN`, each accepted write lands within 4 cycles, and only a write not yet landed changes the field.'''
          milestone: "V2"
          priority: "2"
          security: false
          state: "open: not reviewed for this top"
        }
        {
          name: REQ_WKUP_19b
          desc: '''A write to a detector's configuration shall reach the AON logic within a bounded time.'''
          source: [
            '''!!WKUP_DETECTOR_EN'''
            '''!!WKUP_DETECTOR'''
            '''!!WKUP_DETECTOR_CNT_TH'''
            '''!!WKUP_CAUSE'''
            '''[Wakeup Features](hw/top_darjeeling/ip_autogen/pinmux/doc/programmers_guide.md#wakeup-features)'''
          ]
          kind: "spec"
          testpoint: "wakeup_sync"
          checks: ["write lands (assert_WakeupSync_WriteLands)", "no change without a write (assert_WakeupSync_NoChangeWithoutAWrite)"]
          why: '''For `MODE`, `FILTER` and `MIODIO`, each accepted write lands within 4 cycles and only a write not yet landed changes one.'''
          milestone: "V2"
          priority: "2"
          security: false
          state: "open: not reviewed for this top"
        }
        {
          name: REQ_WKUP_19c
          desc: '''A write to a detector's threshold shall reach the AON logic within a bounded time.'''
          source: [
            '''!!WKUP_DETECTOR_EN'''
            '''!!WKUP_DETECTOR'''
            '''!!WKUP_DETECTOR_CNT_TH'''
            '''!!WKUP_CAUSE'''
            '''[Wakeup Features](hw/top_darjeeling/ip_autogen/pinmux/doc/programmers_guide.md#wakeup-features)'''
          ]
          kind: "spec"
          testpoint: "wakeup_sync"
          checks: ["write lands (assert_WakeupSync_WriteLands)", "no change without a write (assert_WakeupSync_NoChangeWithoutAWrite)"]
          why: '''For `CNT_TH`, each accepted write lands within 4 cycles, and only a write not yet landed changes the field.'''
          milestone: "V2"
          priority: "2"
          security: false
          state: "open: not reviewed for this top"
        }
        {
          name: REQ_WKUP_19d
          desc: '''A clear of `WKUP_CAUSE` shall reach the AON logic within a bounded time.'''
          source: [
            '''!!WKUP_DETECTOR_EN'''
            '''!!WKUP_DETECTOR'''
            '''!!WKUP_DETECTOR_CNT_TH'''
            '''!!WKUP_CAUSE'''
            '''[Wakeup Features](hw/top_darjeeling/ip_autogen/pinmux/doc/programmers_guide.md#wakeup-features)'''
          ]
          kind: "spec"
          testpoint: "wakeup_sync"
          checks: ["clear lands (assert_WakeupSync_ClearLands)", "landed clear clears cause (assert_WakeupSync_LandedClearClearsCause)", "no clear without a write (assert_WakeupSync_NoClearWithoutAWrite)"]
          why: '''A clear lands within 10 cycles, the bit 0 a cycle later; none lands without a write.'''
          milestone: "V2"
          priority: "2"
          security: false
          state: "open: not reviewed for this top"
        }
        {
          name: REQ_WKUP_20a
          desc: '''A write to a detector's *configuration* accepted before a write to its enable shall hold in the AON logic no later than that enable write.'''
          source: [
            '''!!WKUP_DETECTOR_EN'''
          ]
          kind: "spec"
          testpoint: "wakeup_sync"
          checks: ["writes land in order (assert_WakeupSync_WritesLandInOrder)"]
          why: '''It compares the AON cycles in which a configuration write and a later enable write land: the enable may not land first.'''
          milestone: "V2"
          priority: "2"
          security: false
          state: "open: not reviewed for this top"
        }
        {
          name: REQ_WKUP_20b
          desc: '''A write to a detector's *threshold* accepted before a write to its enable shall hold in the AON logic no later than that enable write.'''
          source: [
            '''!!WKUP_DETECTOR_EN'''
          ]
          kind: "spec"
          testpoint: "wakeup_sync"
          checks: ["writes land in order (assert_WakeupSync_WritesLandInOrder)"]
          why: '''It compares the AON cycles in which a threshold write and a later enable write land: an enable that holds before the threshold fails it.'''
          milestone: "V2"
          priority: "2"
          security: false
          state: "open: not reviewed for this top"
        }
      ]
    }
  ]
}
