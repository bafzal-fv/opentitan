// Copyright lowRISC contributors (OpenTitan project).
// Licensed under the Apache License, Version 2.0, see LICENSE for details.
// SPDX-License-Identifier: Apache-2.0
{
  name: "pinmux_fpv"
  // The top the plan was written for and checked on. Other tops render it from the
  // same template with their own parameters; their requirements are not reviewed.
  written_for: "earlgrey"
  rendered_for: "darjeeling"
  spec_commit: "5b8df2b85493add710eb5b8af7d6c263ce9acb87"
  terms: [
    {
      name: '''`n`'''
      desc: '''MIO peripheral input (0 to 3)'''
    }
    {
      name: '''`k`'''
      desc: '''MIO peripheral output (0 to 4)'''
    }
    {
      name: '''`p`'''
      desc: '''MIO pad (0 to 11)'''
    }
    {
      name: '''`d`'''
      desc: '''DIO pad (0 to 72)'''
    }
    {
      name: '''Watched signal'''
      desc: '''The pad input that `MIODIO` and `PADSEL` pick'''
    }
    {
      name: '''Forwarded value'''
      desc: '''The watched signal sampled each `clk_aon_i` cycle, through the filter when `FILTER` is 1'''
    }
  ]
  groups: [
    {
      name: '''Input selection'''
      conditions: [
        '''every row holds in every cycle, except for a JTAG pad while a TAP owns it.'''
      ]
      requirements: [
        {
          name: REQ_IN_01
          desc: '''MIO peripheral input `n` shall read 0 while `MIO_PERIPH_INSEL_n` is 0.'''
          source: [
            '''!!MIO_PERIPH_INSEL.IN'''
          ]
          kind: "spec"
          testpoint: "pad_listen"
          checks: ["CHK_PAD_LISTEN_01 reads tie 0 (assert_PadListen_ReadsTie0)"]
          why: '''In every cycle the check compares each MIO peripheral input whose select is 0 with 0. An input that reads a pad or 1 under select 0, even for one cycle, fails it.'''
          milestone: "V1"
          priority: "1"
          security: false
          state: "open: not reviewed for this top"
        }
        {
          name: REQ_IN_02
          desc: '''MIO peripheral input `n` shall read 1 while `MIO_PERIPH_INSEL_n` is 1.'''
          source: [
            '''!!MIO_PERIPH_INSEL.IN'''
          ]
          kind: "spec"
          testpoint: "pad_listen"
          checks: ["CHK_PAD_LISTEN_02 reads tie 1 (assert_PadListen_ReadsTie1)"]
          why: '''In every cycle the check compares each MIO peripheral input whose select is 1 with 1. An input that reads a pad or 0 under select 1 fails it.'''
          milestone: "V1"
          priority: "1"
          security: false
          state: "open: not reviewed for this top"
        }
        {
          name: REQ_IN_03
          desc: '''MIO peripheral input `n` shall read the input of MIO pad `p`, in the same cycle, while `MIO_PERIPH_INSEL_n` is 2 + `p` (`p` from 0 to 11).'''
          source: [
            '''!!MIO_PERIPH_INSEL.IN'''
            '''[top_darjeeling_pinmux.ipconfig.hjson `n_mio_pads`](hw/top_darjeeling/ip_autogen/pinmux/data/top_darjeeling_pinmux.ipconfig.hjson)'''
          ]
          kind: "spec"
          testpoint: "pad_listen"
          checks: ["CHK_PAD_LISTEN_03 reads selected pad (assert_PadListen_ReadsSelectedPad)"]
          why: '''For each select from 2 to 13 the check compares the input with `mio_in_i` of pad select minus 2, in the same cycle. An input that reads another pad, or the right pad a cycle late, differs in some cycle and fails it.'''
          milestone: "V1"
          priority: "1"
          security: false
          state: "open: not reviewed for this top"
        }
        {
          name: REQ_IN_04
          desc: '''MIO peripheral input `n` shall read 0 while `MIO_PERIPH_INSEL_n` is 14 to 15, the values that name no pad.'''
          source: [
            '''!!MIO_PERIPH_INSEL'''
            '''[top_darjeeling_pinmux.ipconfig.hjson `n_mio_pads`](hw/top_darjeeling/ip_autogen/pinmux/data/top_darjeeling_pinmux.ipconfig.hjson)'''
          ]
          kind: "RTL"
          testpoint: "pad_listen"
          checks: ["CHK_PAD_LISTEN_04 no pad reads 0 (assert_PadListen_NoPadReads0)"]
          why: '''For selects 14 to 15, which name no pad, the check compares the input with 0. An input that reads a pad there, for example by wrapping the select around, or reads 1, fails it.'''
          milestone: "V1"
          priority: "1"
          security: false
          state: "open: not reviewed for this top"
        }
        {
          name: REQ_IN_05
          desc: '''DIO peripheral input `d` shall read the input of DIO pad `d`, in the same cycle, whatever the registers hold.'''
          source: [
            '''[MIO and DIO Signal Categories](hw/top_darjeeling/ip_autogen/pinmux/doc/theory_of_operation.md#mio-and-dio-signal-categories)'''
          ]
          kind: "spec"
          testpoint: "pad_listen"
          checks: ["CHK_PAD_LISTEN_05 DIO reads its pad (assert_PadListen_DIOReadsItsPad)"]
          why: '''The check compares each DIO peripheral input with its own pad's `dio_in_i` in the same cycle, whatever the registers hold. An input that reads another DIO pad, depends on a register or lags by a cycle fails it.'''
          milestone: "V1"
          priority: "1"
          security: false
          state: "open: not reviewed for this top"
        }
        {
          name: REQ_IN_06
          desc: '''After reset, every MIO peripheral input shall read 0 until software writes its select.'''
          source: [
            '''[Pinmux Configuration](hw/top_darjeeling/ip_autogen/pinmux/doc/programmers_guide.md#pinmux-configuration)'''
            '''[MIO and DIO Signal Categories](hw/top_darjeeling/ip_autogen/pinmux/doc/theory_of_operation.md#mio-and-dio-signal-categories)'''
            '''!!MIO_PERIPH_INSEL.IN'''
          ]
          kind: "spec"
          testpoint: "reset_state"
          checks: ["CHK_PAD_LISTEN_01 reads tie 0 (assert_PadListen_ReadsTie0)"]
          why: '''The generated register checker keeps each input select at its reset value 0 until software writes it, and _reads tie 0_ (CHK_PAD_LISTEN_01) makes an input whose select is 0 read 0 in the same cycle. An input that reads 1 before its select is written fails one of the two.'''
          milestone: "V2"
          priority: "2"
          security: false
          state: "open: not reviewed for this top"
        }
      ]
    }
    {
      name: '''Output selection'''
      conditions: [
        '''every row holds while the pad's sleep mode is not active (Sleep retention) and no TAP owns the pad.'''
      ]
      requirements: [
        {
          name: REQ_OUT_01a
          desc: '''The output of MIO pad `p` shall be 0 while `MIO_OUTSEL_p` is 0.'''
          source: [
            '''!!MIO_OUTSEL.OUT'''
          ]
          kind: "spec"
          testpoint: "pad_output"
          checks: ["CHK_PAD_OUTPUT_01 tie 0 drives 0 (assert_PadOutput_Tie0Drives0)"]
          why: '''While an awake pad's select is 0, the check compares the pad's output with 0 in every cycle. A pad that puts 1 or a peripheral's data on its output there fails it.'''
          milestone: "V1"
          priority: "1"
          security: false
          state: "open: not reviewed for this top"
        }
        {
          name: REQ_OUT_01b
          desc: '''The output enable of MIO pad `p` shall be 1 while `MIO_OUTSEL_p` is 0, so the pad drives 0.'''
          source: [
            '''!!MIO_OUTSEL.OUT'''
          ]
          kind: "spec"
          testpoint: "pad_output"
          checks: ["CHK_PAD_OUTPUT_01 tie 0 drives 0 (assert_PadOutput_Tie0Drives0)"]
          why: '''Under select 0 the check compares the pad's output enable with 1 in every cycle. A pad left high-Z, or following a peripheral's enable, under select 0 fails it.'''
          milestone: "V1"
          priority: "1"
          security: false
          state: "open: not reviewed for this top"
        }
        {
          name: REQ_OUT_02a
          desc: '''The output of MIO pad `p` shall be 1 while `MIO_OUTSEL_p` is 1.'''
          source: [
            '''!!MIO_OUTSEL.OUT'''
          ]
          kind: "spec"
          testpoint: "pad_output"
          checks: ["CHK_PAD_OUTPUT_02 tie 1 drives 1 (assert_PadOutput_Tie1Drives1)"]
          why: '''While an awake pad's select is 1, the check compares the pad's output with 1 in every cycle. A pad that puts 0 or a peripheral's data on its output there fails it.'''
          milestone: "V1"
          priority: "1"
          security: false
          state: "open: not reviewed for this top"
        }
        {
          name: REQ_OUT_02b
          desc: '''The output enable of MIO pad `p` shall be 1 while `MIO_OUTSEL_p` is 1, so the pad drives 1.'''
          source: [
            '''!!MIO_OUTSEL.OUT'''
          ]
          kind: "spec"
          testpoint: "pad_output"
          checks: ["CHK_PAD_OUTPUT_02 tie 1 drives 1 (assert_PadOutput_Tie1Drives1)"]
          why: '''Under select 1 the check compares the pad's output enable with 1 in every cycle. A pad left high-Z, or following a peripheral's enable, under select 1 fails it.'''
          milestone: "V1"
          priority: "1"
          security: false
          state: "open: not reviewed for this top"
        }
        {
          name: REQ_OUT_03a
          desc: '''The output enable of MIO pad `p` shall be 0 while `MIO_OUTSEL_p` is 2: the pad is high-Z.'''
          source: [
            '''!!MIO_OUTSEL.OUT'''
          ]
          kind: "spec"
          testpoint: "pad_output"
          checks: ["CHK_PAD_OUTPUT_03 select 2 is high-Z (assert_PadOutput_Select2IsHighZ)"]
          why: '''While an awake pad's select is 2, the check compares the pad's output enable with 0 in every cycle. A pad that drives under select 2, even for one cycle, fails it.'''
          milestone: "V1"
          priority: "1"
          security: false
          state: "open: not reviewed for this top"
        }
        {
          name: REQ_OUT_03b
          desc: '''The output of MIO pad `p` shall be 0 while `MIO_OUTSEL_p` is 2.'''
          source: [
            '''!!MIO_OUTSEL.OUT'''
          ]
          kind: "spec"
          testpoint: "pad_output"
          checks: ["CHK_PAD_OUTPUT_03 select 2 is high-Z (assert_PadOutput_Select2IsHighZ)"]
          why: '''Under select 2 the check compares the pad's output with 0 in every cycle. A pad that puts 1 or a peripheral's data on its output while high-Z fails it.'''
          milestone: "V1"
          priority: "1"
          security: false
          state: "open: not reviewed for this top"
        }
        {
          name: REQ_OUT_04a
          desc: '''MIO pad `p` shall carry peripheral output `k`, in the same cycle, while `MIO_OUTSEL_p` is 3 + `k` (`k` from 0 to 4).'''
          source: [
            '''!!MIO_OUTSEL.OUT'''
            '''[Muxing Matrix](hw/top_darjeeling/ip_autogen/pinmux/doc/theory_of_operation.md#muxing-matrix)'''
            '''[top_darjeeling_pinmux.ipconfig.hjson `n_mio_periph_out`](hw/top_darjeeling/ip_autogen/pinmux/data/top_darjeeling_pinmux.ipconfig.hjson)'''
          ]
          kind: "spec"
          testpoint: "pad_output"
          checks: ["CHK_PAD_OUTPUT_04 drives selected output (assert_PadOutput_DrivesSelectedOutput)"]
          why: '''For each select from 3 to 7 the check compares the pad's output with `periph_to_mio_i[k]`, `k` the select minus 3, in the same cycle. A pad that carries another output's data, or the right data a cycle late, fails it.'''
          milestone: "V1"
          priority: "1"
          security: false
          state: "open: not reviewed for this top"
        }
        {
          name: REQ_OUT_04b
          desc: '''MIO pad `p` shall carry output enable `k`, in the same cycle, while `MIO_OUTSEL_p` is 3 + `k` (`k` from 0 to 4).'''
          source: [
            '''!!MIO_OUTSEL.OUT'''
            '''[Muxing Matrix](hw/top_darjeeling/ip_autogen/pinmux/doc/theory_of_operation.md#muxing-matrix)'''
            '''[top_darjeeling_pinmux.ipconfig.hjson `n_mio_periph_out`](hw/top_darjeeling/ip_autogen/pinmux/data/top_darjeeling_pinmux.ipconfig.hjson)'''
          ]
          kind: "spec"
          testpoint: "pad_output"
          checks: ["CHK_PAD_OUTPUT_04 drives selected output (assert_PadOutput_DrivesSelectedOutput)"]
          why: '''The check compares the pad's output enable with `periph_to_mio_oe_i[k]` in the same cycle, together with the data. A pad that pairs one output's data with another output's enable, or lags the enable by a cycle, fails it.'''
          milestone: "V1"
          priority: "1"
          security: false
          state: "open: not reviewed for this top"
        }
        {
          name: REQ_OUT_05a
          desc: '''The output enable of MIO pad `p` shall be 0 while `MIO_OUTSEL_p` is above 7 (no such value on this top), the values that name no peripheral output: the pad is high-Z.'''
          source: [
            '''!!MIO_OUTSEL'''
            '''[top_darjeeling_pinmux.ipconfig.hjson `n_mio_periph_out`](hw/top_darjeeling/ip_autogen/pinmux/data/top_darjeeling_pinmux.ipconfig.hjson)'''
          ]
          kind: "RTL"
          testpoint: "pad_output"
          checks: ["CHK_PAD_OUTPUT_05 no output is high-Z (assert_PadOutput_NoOutputIsHighZ)"]
          why: '''For selects above 7 (no such value on this top), which name no output, the check compares the pad's output enable with 0. A pad that drives there, for example by wrapping the select onto a real output, fails it.'''
          milestone: "V1"
          priority: "1"
          security: false
          state: "open: not reviewed for this top"
        }
        {
          name: REQ_OUT_05b
          desc: '''The output of MIO pad `p` shall be 0 while `MIO_OUTSEL_p` is above 7 (no such value on this top), the values that name no peripheral output.'''
          source: [
            '''!!MIO_OUTSEL'''
            '''[top_darjeeling_pinmux.ipconfig.hjson `n_mio_periph_out`](hw/top_darjeeling/ip_autogen/pinmux/data/top_darjeeling_pinmux.ipconfig.hjson)'''
          ]
          kind: "RTL"
          testpoint: "pad_output"
          checks: ["CHK_PAD_OUTPUT_05 no output is high-Z (assert_PadOutput_NoOutputIsHighZ)"]
          why: '''For selects above 7 (no such value on this top) the check compares the pad's output with 0. A pad that puts 1 or any output's data on its output there fails it.'''
          milestone: "V1"
          priority: "1"
          security: false
          state: "open: not reviewed for this top"
        }
        {
          name: REQ_OUT_06a
          desc: '''DIO pad `d` shall carry its peripheral's output, in the same cycle.'''
          source: [
            '''[MIO and DIO Signal Categories](hw/top_darjeeling/ip_autogen/pinmux/doc/theory_of_operation.md#mio-and-dio-signal-categories)'''
          ]
          kind: "spec"
          testpoint: "pad_output"
          checks: ["CHK_PAD_OUTPUT_06 DIO drives its peripheral (assert_PadOutput_DIODrivesItsPeripheral)"]
          why: '''The check compares each awake DIO pad's output with its own peripheral's, `periph_to_dio_i[d]`, in the same cycle, whatever the registers hold. A pad that carries another peripheral, depends on a register or lags by a cycle fails it.'''
          milestone: "V1"
          priority: "1"
          security: false
          state: "open: not reviewed for this top"
        }
        {
          name: REQ_OUT_06b
          desc: '''DIO pad `d` shall carry its peripheral's output enable, in the same cycle.'''
          source: [
            '''[MIO and DIO Signal Categories](hw/top_darjeeling/ip_autogen/pinmux/doc/theory_of_operation.md#mio-and-dio-signal-categories)'''
          ]
          kind: "spec"
          testpoint: "pad_output"
          checks: ["CHK_PAD_OUTPUT_06 DIO drives its peripheral (assert_PadOutput_DIODrivesItsPeripheral)"]
          why: '''The check compares each awake DIO pad's output enable with `periph_to_dio_oe_i[d]` in the same cycle, whatever the registers hold. A pad that takes another peripheral's enable, or lags by a cycle, fails it.'''
          milestone: "V1"
          priority: "1"
          security: false
          state: "open: not reviewed for this top"
        }
        {
          name: REQ_OUT_07
          desc: '''After reset, every MIO pad shall be high-Z until software writes its select.'''
          source: [
            '''[MIO and DIO Signal Categories](hw/top_darjeeling/ip_autogen/pinmux/doc/theory_of_operation.md#mio-and-dio-signal-categories)'''
            '''[Pinmux Configuration](hw/top_darjeeling/ip_autogen/pinmux/doc/programmers_guide.md#pinmux-configuration)'''
            '''!!MIO_OUTSEL.OUT'''
          ]
          kind: "spec"
          testpoint: "reset_state"
          checks: ["CHK_PAD_OUTPUT_03 select 2 is high-Z (assert_PadOutput_Select2IsHighZ)"]
          why: '''The generated register checker keeps each output select at its reset value 2 until software writes it, and _select 2 is high-Z_ (CHK_PAD_OUTPUT_03) makes an awake pad that no TAP owns drive (0, 0) on select 2. A pad that drives before its select is written fails one of the two; an asleep pad and a JTAG pad a TAP owns are decided by the sleep and JTAG pad checks.'''
          milestone: "V2"
          priority: "2"
          security: false
          state: "open: not reviewed for this top"
        }
      ]
    }
    {
      name: '''Pad attributes'''
      conditions: [
        '''every row holds in every cycle, asleep or awake, except on a JTAG pad while a TAP owns it. "Written" means a write the register block accepts, its lock open (Register locks); "reads back" means what a read of the register returns. A pad type "keeps" an attribute bit when its pads implement that bit ([Pad Attributes](hw/top_darjeeling/ip_autogen/pinmux/doc/programmers_guide.md#pad-attributes)); which bits a type keeps is fixed, the same on every pad of the type and for good. A one-bit field is kept when its bit is; each bit of `slew_rate` and `drive_strength` is kept or not on its own, as "certain pads may only support two drive-strength bits, instead of four" ([Pad Attributes](hw/top_darjeeling/ip_autogen/pinmux/doc/programmers_guide.md#pad-attributes)). Every pad keeps `invert` ([Generic Pad Wrapper](hw/top_darjeeling/ip_autogen/pinmux/doc/theory_of_operation.md#generic-pad-wrapper)).'''
      ]
      requirements: [
        {
          name: REQ_ATTR_01a
          desc: '''The attribute output of MIO pad `p` shall equal, in field `invert`, what `MIO_PAD_ATTR_p` reads back.'''
          source: [
            '''!!MIO_PAD_ATTR.invert'''
            '''[Type RW HWExt](util/reggen/README.md#type-rw-hwext)'''
            '''[Generic Pad Wrapper](hw/top_darjeeling/ip_autogen/pinmux/doc/theory_of_operation.md#generic-pad-wrapper)'''
          ]
          kind: "spec"
          testpoint: "pad_attr"
          checks: ["CHK_PAD_ATTR_01 pad gets read-back (assert_PadAttr_PadGetsReadBack)"]
          why: '''In every cycle the check compares field `invert` of `mio_attr_o` for the pad with the same field of what a read of `MIO_PAD_ATTR_p` returns. A pad that inverts while the register reads 0, or the reverse, or takes the bit a cycle late, fails it.'''
          milestone: "V2"
          priority: "2"
          security: false
          state: "open: not reviewed for this top"
        }
        {
          name: REQ_ATTR_01b
          desc: '''The attribute output of MIO pad `p` shall equal, in field `virtual_od_en`, what `MIO_PAD_ATTR_p` reads back.'''
          source: [
            '''!!MIO_PAD_ATTR.virtual_od_en'''
            '''[Type RW HWExt](util/reggen/README.md#type-rw-hwext)'''
            '''[Generic Pad Wrapper](hw/top_darjeeling/ip_autogen/pinmux/doc/theory_of_operation.md#generic-pad-wrapper)'''
          ]
          kind: "spec"
          testpoint: "pad_attr"
          checks: ["CHK_PAD_ATTR_01 pad gets read-back (assert_PadAttr_PadGetsReadBack)"]
          why: '''In every cycle the check compares field `virtual_od_en` of the pad's `mio_attr_o` with the same field of the read-back of `MIO_PAD_ATTR_p`. A pad that gets a virtual open drain the register does not show, or loses one it shows, fails it.'''
          milestone: "V2"
          priority: "2"
          security: false
          state: "open: not reviewed for this top"
        }
        {
          name: REQ_ATTR_01c
          desc: '''The attribute output of MIO pad `p` shall equal, in field `pull_en`, what `MIO_PAD_ATTR_p` reads back.'''
          source: [
            '''!!MIO_PAD_ATTR.pull_en'''
            '''[Type RW HWExt](util/reggen/README.md#type-rw-hwext)'''
            '''[Generic Pad Wrapper](hw/top_darjeeling/ip_autogen/pinmux/doc/theory_of_operation.md#generic-pad-wrapper)'''
          ]
          kind: "spec"
          testpoint: "pad_attr"
          checks: ["CHK_PAD_ATTR_01 pad gets read-back (assert_PadAttr_PadGetsReadBack)"]
          why: '''In every cycle the check compares field `pull_en` of the pad's `mio_attr_o` with the same field of the read-back of `MIO_PAD_ATTR_p`. A pad that gets a pull the register does not show, or loses one it shows, fails it.'''
          milestone: "V2"
          priority: "2"
          security: false
          state: "open: not reviewed for this top"
        }
        {
          name: REQ_ATTR_01d
          desc: '''The attribute output of MIO pad `p` shall equal, in field `pull_select`, what `MIO_PAD_ATTR_p` reads back.'''
          source: [
            '''!!MIO_PAD_ATTR.pull_select'''
            '''[Type RW HWExt](util/reggen/README.md#type-rw-hwext)'''
            '''[Generic Pad Wrapper](hw/top_darjeeling/ip_autogen/pinmux/doc/theory_of_operation.md#generic-pad-wrapper)'''
          ]
          kind: "spec"
          testpoint: "pad_attr"
          checks: ["CHK_PAD_ATTR_01 pad gets read-back (assert_PadAttr_PadGetsReadBack)"]
          why: '''In every cycle the check compares field `pull_select` of the pad's `mio_attr_o` with the same field of the read-back of `MIO_PAD_ATTR_p`. A pad pulled the other way from what the register shows fails it.'''
          milestone: "V2"
          priority: "2"
          security: false
          state: "open: not reviewed for this top"
        }
        {
          name: REQ_ATTR_01e
          desc: '''The attribute output of MIO pad `p` shall equal, in field `keeper_en`, what `MIO_PAD_ATTR_p` reads back.'''
          source: [
            '''!!MIO_PAD_ATTR.keeper_en'''
            '''[Type RW HWExt](util/reggen/README.md#type-rw-hwext)'''
            '''[Generic Pad Wrapper](hw/top_darjeeling/ip_autogen/pinmux/doc/theory_of_operation.md#generic-pad-wrapper)'''
          ]
          kind: "spec"
          testpoint: "pad_attr"
          checks: ["CHK_PAD_ATTR_01 pad gets read-back (assert_PadAttr_PadGetsReadBack)"]
          why: '''In every cycle the check compares field `keeper_en` of the pad's `mio_attr_o` with the same field of the read-back of `MIO_PAD_ATTR_p`. A pad whose keeper is on while the register shows it off, or the reverse, fails it.'''
          milestone: "V2"
          priority: "2"
          security: false
          state: "open: not reviewed for this top"
        }
        {
          name: REQ_ATTR_01f
          desc: '''The attribute output of MIO pad `p` shall equal, in field `schmitt_en`, what `MIO_PAD_ATTR_p` reads back.'''
          source: [
            '''!!MIO_PAD_ATTR.schmitt_en'''
            '''[Type RW HWExt](util/reggen/README.md#type-rw-hwext)'''
            '''[Generic Pad Wrapper](hw/top_darjeeling/ip_autogen/pinmux/doc/theory_of_operation.md#generic-pad-wrapper)'''
          ]
          kind: "spec"
          testpoint: "pad_attr"
          checks: ["CHK_PAD_ATTR_01 pad gets read-back (assert_PadAttr_PadGetsReadBack)"]
          why: '''In every cycle the check compares field `schmitt_en` of the pad's `mio_attr_o` with the same field of the read-back of `MIO_PAD_ATTR_p`. A pad whose Schmitt trigger differs from what the register shows fails it.'''
          milestone: "V2"
          priority: "2"
          security: false
          state: "open: not reviewed for this top"
        }
        {
          name: REQ_ATTR_01g
          desc: '''The attribute output of MIO pad `p` shall equal, in field `od_en`, what `MIO_PAD_ATTR_p` reads back.'''
          source: [
            '''!!MIO_PAD_ATTR.od_en'''
            '''[Type RW HWExt](util/reggen/README.md#type-rw-hwext)'''
            '''[Generic Pad Wrapper](hw/top_darjeeling/ip_autogen/pinmux/doc/theory_of_operation.md#generic-pad-wrapper)'''
          ]
          kind: "spec"
          testpoint: "pad_attr"
          checks: ["CHK_PAD_ATTR_01 pad gets read-back (assert_PadAttr_PadGetsReadBack)"]
          why: '''In every cycle the check compares field `od_en` of the pad's `mio_attr_o` with the same field of the read-back of `MIO_PAD_ATTR_p`. A pad set to open drain while the register shows push-pull, or the reverse, fails it.'''
          milestone: "V2"
          priority: "2"
          security: false
          state: "open: not reviewed for this top"
        }
        {
          name: REQ_ATTR_01h
          desc: '''The attribute output of MIO pad `p` shall equal, in field `input_disable`, what `MIO_PAD_ATTR_p` reads back.'''
          source: [
            '''!!MIO_PAD_ATTR.input_disable'''
            '''[Type RW HWExt](util/reggen/README.md#type-rw-hwext)'''
            '''[Generic Pad Wrapper](hw/top_darjeeling/ip_autogen/pinmux/doc/theory_of_operation.md#generic-pad-wrapper)'''
          ]
          kind: "spec"
          testpoint: "pad_attr"
          checks: ["CHK_PAD_ATTR_01 pad gets read-back (assert_PadAttr_PadGetsReadBack)"]
          why: '''In every cycle the check compares field `input_disable` of the pad's `mio_attr_o` with the same field of the read-back of `MIO_PAD_ATTR_p`. A pad whose input is cut off while the register shows it on, or the reverse, fails it.'''
          milestone: "V2"
          priority: "2"
          security: false
          state: "open: not reviewed for this top"
        }
        {
          name: REQ_ATTR_01i
          desc: '''The attribute output of MIO pad `p` shall equal, in field `slew_rate`, what `MIO_PAD_ATTR_p` reads back.'''
          source: [
            '''!!MIO_PAD_ATTR.slew_rate'''
            '''[Type RW HWExt](util/reggen/README.md#type-rw-hwext)'''
            '''[Generic Pad Wrapper](hw/top_darjeeling/ip_autogen/pinmux/doc/theory_of_operation.md#generic-pad-wrapper)'''
          ]
          kind: "spec"
          testpoint: "pad_attr"
          checks: ["CHK_PAD_ATTR_01 pad gets read-back (assert_PadAttr_PadGetsReadBack)"]
          why: '''In every cycle the check compares both bits of field `slew_rate` of the pad's `mio_attr_o` with the read-back of `MIO_PAD_ATTR_p`. A pad that gets another slew rate than the register shows fails it.'''
          milestone: "V2"
          priority: "2"
          security: false
          state: "open: not reviewed for this top"
        }
        {
          name: REQ_ATTR_01j
          desc: '''The attribute output of MIO pad `p` shall equal, in field `drive_strength`, what `MIO_PAD_ATTR_p` reads back.'''
          source: [
            '''!!MIO_PAD_ATTR.drive_strength'''
            '''[Type RW HWExt](util/reggen/README.md#type-rw-hwext)'''
            '''[Generic Pad Wrapper](hw/top_darjeeling/ip_autogen/pinmux/doc/theory_of_operation.md#generic-pad-wrapper)'''
          ]
          kind: "spec"
          testpoint: "pad_attr"
          checks: ["CHK_PAD_ATTR_01 pad gets read-back (assert_PadAttr_PadGetsReadBack)"]
          why: '''In every cycle the check compares the four bits of field `drive_strength` of the pad's `mio_attr_o` with the read-back of `MIO_PAD_ATTR_p`. A pad that gets another drive strength than the register shows fails it.'''
          milestone: "V2"
          priority: "2"
          security: false
          state: "open: not reviewed for this top"
        }
        {
          name: REQ_ATTR_02a
          desc: '''The attribute output of DIO pad `d` shall equal, in field `invert`, what `DIO_PAD_ATTR_d` reads back.'''
          source: [
            '''!!DIO_PAD_ATTR.invert'''
            '''[Type RW HWExt](util/reggen/README.md#type-rw-hwext)'''
            '''[Generic Pad Wrapper](hw/top_darjeeling/ip_autogen/pinmux/doc/theory_of_operation.md#generic-pad-wrapper)'''
          ]
          kind: "spec"
          testpoint: "pad_attr"
          checks: ["CHK_PAD_ATTR_01 pad gets read-back (assert_PadAttr_PadGetsReadBack)"]
          why: '''In every cycle the check compares field `invert` of `dio_attr_o` for the pad with the same field of what a read of `DIO_PAD_ATTR_d` returns. A pad that inverts while the register reads 0, or the reverse, or takes the bit a cycle late, fails it.'''
          milestone: "V2"
          priority: "2"
          security: false
          state: "open: not reviewed for this top"
        }
        {
          name: REQ_ATTR_02b
          desc: '''The attribute output of DIO pad `d` shall equal, in field `virtual_od_en`, what `DIO_PAD_ATTR_d` reads back.'''
          source: [
            '''!!DIO_PAD_ATTR.virtual_od_en'''
            '''[Type RW HWExt](util/reggen/README.md#type-rw-hwext)'''
            '''[Generic Pad Wrapper](hw/top_darjeeling/ip_autogen/pinmux/doc/theory_of_operation.md#generic-pad-wrapper)'''
          ]
          kind: "spec"
          testpoint: "pad_attr"
          checks: ["CHK_PAD_ATTR_01 pad gets read-back (assert_PadAttr_PadGetsReadBack)"]
          why: '''In every cycle the check compares field `virtual_od_en` of the pad's `dio_attr_o` with the same field of the read-back of `DIO_PAD_ATTR_d`. A pad that gets a virtual open drain the register does not show, or loses one it shows, fails it.'''
          milestone: "V2"
          priority: "2"
          security: false
          state: "open: not reviewed for this top"
        }
        {
          name: REQ_ATTR_02c
          desc: '''The attribute output of DIO pad `d` shall equal, in field `pull_en`, what `DIO_PAD_ATTR_d` reads back.'''
          source: [
            '''!!DIO_PAD_ATTR.pull_en'''
            '''[Type RW HWExt](util/reggen/README.md#type-rw-hwext)'''
            '''[Generic Pad Wrapper](hw/top_darjeeling/ip_autogen/pinmux/doc/theory_of_operation.md#generic-pad-wrapper)'''
          ]
          kind: "spec"
          testpoint: "pad_attr"
          checks: ["CHK_PAD_ATTR_01 pad gets read-back (assert_PadAttr_PadGetsReadBack)"]
          why: '''In every cycle the check compares field `pull_en` of the pad's `dio_attr_o` with the same field of the read-back of `DIO_PAD_ATTR_d`. A pad that gets a pull the register does not show, or loses one it shows, fails it.'''
          milestone: "V2"
          priority: "2"
          security: false
          state: "open: not reviewed for this top"
        }
        {
          name: REQ_ATTR_02d
          desc: '''The attribute output of DIO pad `d` shall equal, in field `pull_select`, what `DIO_PAD_ATTR_d` reads back.'''
          source: [
            '''!!DIO_PAD_ATTR.pull_select'''
            '''[Type RW HWExt](util/reggen/README.md#type-rw-hwext)'''
            '''[Generic Pad Wrapper](hw/top_darjeeling/ip_autogen/pinmux/doc/theory_of_operation.md#generic-pad-wrapper)'''
          ]
          kind: "spec"
          testpoint: "pad_attr"
          checks: ["CHK_PAD_ATTR_01 pad gets read-back (assert_PadAttr_PadGetsReadBack)"]
          why: '''In every cycle the check compares field `pull_select` of the pad's `dio_attr_o` with the same field of the read-back of `DIO_PAD_ATTR_d`. A pad pulled the other way from what the register shows fails it.'''
          milestone: "V2"
          priority: "2"
          security: false
          state: "open: not reviewed for this top"
        }
        {
          name: REQ_ATTR_02e
          desc: '''The attribute output of DIO pad `d` shall equal, in field `keeper_en`, what `DIO_PAD_ATTR_d` reads back.'''
          source: [
            '''!!DIO_PAD_ATTR.keeper_en'''
            '''[Type RW HWExt](util/reggen/README.md#type-rw-hwext)'''
            '''[Generic Pad Wrapper](hw/top_darjeeling/ip_autogen/pinmux/doc/theory_of_operation.md#generic-pad-wrapper)'''
          ]
          kind: "spec"
          testpoint: "pad_attr"
          checks: ["CHK_PAD_ATTR_01 pad gets read-back (assert_PadAttr_PadGetsReadBack)"]
          why: '''In every cycle the check compares field `keeper_en` of the pad's `dio_attr_o` with the same field of the read-back of `DIO_PAD_ATTR_d`. A pad whose keeper is on while the register shows it off, or the reverse, fails it.'''
          milestone: "V2"
          priority: "2"
          security: false
          state: "open: not reviewed for this top"
        }
        {
          name: REQ_ATTR_02f
          desc: '''The attribute output of DIO pad `d` shall equal, in field `schmitt_en`, what `DIO_PAD_ATTR_d` reads back.'''
          source: [
            '''!!DIO_PAD_ATTR.schmitt_en'''
            '''[Type RW HWExt](util/reggen/README.md#type-rw-hwext)'''
            '''[Generic Pad Wrapper](hw/top_darjeeling/ip_autogen/pinmux/doc/theory_of_operation.md#generic-pad-wrapper)'''
          ]
          kind: "spec"
          testpoint: "pad_attr"
          checks: ["CHK_PAD_ATTR_01 pad gets read-back (assert_PadAttr_PadGetsReadBack)"]
          why: '''In every cycle the check compares field `schmitt_en` of the pad's `dio_attr_o` with the same field of the read-back of `DIO_PAD_ATTR_d`. A pad whose Schmitt trigger differs from what the register shows fails it.'''
          milestone: "V2"
          priority: "2"
          security: false
          state: "open: not reviewed for this top"
        }
        {
          name: REQ_ATTR_02g
          desc: '''The attribute output of DIO pad `d` shall equal, in field `od_en`, what `DIO_PAD_ATTR_d` reads back.'''
          source: [
            '''!!DIO_PAD_ATTR.od_en'''
            '''[Type RW HWExt](util/reggen/README.md#type-rw-hwext)'''
            '''[Generic Pad Wrapper](hw/top_darjeeling/ip_autogen/pinmux/doc/theory_of_operation.md#generic-pad-wrapper)'''
          ]
          kind: "spec"
          testpoint: "pad_attr"
          checks: ["CHK_PAD_ATTR_01 pad gets read-back (assert_PadAttr_PadGetsReadBack)"]
          why: '''In every cycle the check compares field `od_en` of the pad's `dio_attr_o` with the same field of the read-back of `DIO_PAD_ATTR_d`. A pad set to open drain while the register shows push-pull, or the reverse, fails it.'''
          milestone: "V2"
          priority: "2"
          security: false
          state: "open: not reviewed for this top"
        }
        {
          name: REQ_ATTR_02h
          desc: '''The attribute output of DIO pad `d` shall equal, in field `input_disable`, what `DIO_PAD_ATTR_d` reads back.'''
          source: [
            '''!!DIO_PAD_ATTR.input_disable'''
            '''[Type RW HWExt](util/reggen/README.md#type-rw-hwext)'''
            '''[Generic Pad Wrapper](hw/top_darjeeling/ip_autogen/pinmux/doc/theory_of_operation.md#generic-pad-wrapper)'''
          ]
          kind: "spec"
          testpoint: "pad_attr"
          checks: ["CHK_PAD_ATTR_01 pad gets read-back (assert_PadAttr_PadGetsReadBack)"]
          why: '''In every cycle the check compares field `input_disable` of the pad's `dio_attr_o` with the same field of the read-back of `DIO_PAD_ATTR_d`. A pad whose input is cut off while the register shows it on, or the reverse, fails it.'''
          milestone: "V2"
          priority: "2"
          security: false
          state: "open: not reviewed for this top"
        }
        {
          name: REQ_ATTR_02i
          desc: '''The attribute output of DIO pad `d` shall equal, in field `slew_rate`, what `DIO_PAD_ATTR_d` reads back.'''
          source: [
            '''!!DIO_PAD_ATTR.slew_rate'''
            '''[Type RW HWExt](util/reggen/README.md#type-rw-hwext)'''
            '''[Generic Pad Wrapper](hw/top_darjeeling/ip_autogen/pinmux/doc/theory_of_operation.md#generic-pad-wrapper)'''
          ]
          kind: "spec"
          testpoint: "pad_attr"
          checks: ["CHK_PAD_ATTR_01 pad gets read-back (assert_PadAttr_PadGetsReadBack)"]
          why: '''In every cycle the check compares both bits of field `slew_rate` of the pad's `dio_attr_o` with the read-back of `DIO_PAD_ATTR_d`. A pad that gets another slew rate than the register shows fails it.'''
          milestone: "V2"
          priority: "2"
          security: false
          state: "open: not reviewed for this top"
        }
        {
          name: REQ_ATTR_02j
          desc: '''The attribute output of DIO pad `d` shall equal, in field `drive_strength`, what `DIO_PAD_ATTR_d` reads back.'''
          source: [
            '''!!DIO_PAD_ATTR.drive_strength'''
            '''[Type RW HWExt](util/reggen/README.md#type-rw-hwext)'''
            '''[Generic Pad Wrapper](hw/top_darjeeling/ip_autogen/pinmux/doc/theory_of_operation.md#generic-pad-wrapper)'''
          ]
          kind: "spec"
          testpoint: "pad_attr"
          checks: ["CHK_PAD_ATTR_01 pad gets read-back (assert_PadAttr_PadGetsReadBack)"]
          why: '''In every cycle the check compares the four bits of field `drive_strength` of the pad's `dio_attr_o` with the read-back of `DIO_PAD_ATTR_d`. A pad that gets another drive strength than the register shows fails it.'''
          milestone: "V2"
          priority: "2"
          security: false
          state: "open: not reviewed for this top"
        }
        {
          name: REQ_ATTR_03
          desc: '''The `invert` field of every pad shall read back as written.'''
          source: [
            '''[Generic Pad Wrapper](hw/top_darjeeling/ip_autogen/pinmux/doc/theory_of_operation.md#generic-pad-wrapper)'''
          ]
          kind: "spec"
          testpoint: "pad_attr"
          checks: ["CHK_PAD_ATTR_02 invert reads back (assert_PadAttr_InvertReadsBack)"]
          why: '''On every pad type, from the pad's first attribute write on, the check compares the `invert` bit of the read-back with the `invert` bit of the last attribute write. A pad type that drops inversion, reading 0 after a write of 1, fails it; with _pad gets read-back_ (CHK_PAD_ATTR_01) the pad then inverts as written.'''
          milestone: "V2"
          priority: "2"
          security: false
          state: "open: not reviewed for this top"
        }
        {
          name: REQ_ATTR_04
          desc: '''The `od_en` field of a BidirOd pad shall read back as written.'''
          source: [
            '''[Open drain / virtual open drain](hw/top_earlgrey/doc/design/README.md#open-drain--virtual-open-drain)'''
            '''[top_darjeeling.hjson](hw/top_darjeeling/data/top_darjeeling.hjson)'''
          ]
          kind: "spec"
          testpoint: "pad_attr"
          checks: ["CHK_PAD_ATTR_03 open drain reads back (assert_PadAttr_OpenDrainReadsBack)"]
          why: '''On every BidirOd pad, from the pad's first attribute write on, the check compares the `od_en` bit of the read-back with the `od_en` bit of the pad's last attribute write. A BidirOd pad whose `od_en` reads 0 after a write of 1, or keeps an older value, fails it.'''
          milestone: "V2"
          priority: "2"
          security: false
          state: "open: not reviewed for this top"
        }
        {
          name: REQ_ATTR_05
          desc: '''The `virtual_od_en` field of a BidirStd pad shall read back as written.'''
          source: [
            '''[Open drain / virtual open drain](hw/top_earlgrey/doc/design/README.md#open-drain--virtual-open-drain)'''
            '''[top_darjeeling.hjson](hw/top_darjeeling/data/top_darjeeling.hjson)'''
          ]
          kind: "spec"
          testpoint: "pad_attr"
          checks: ["CHK_PAD_ATTR_04 virtual open drain reads back (assert_PadAttr_VirtualOpenDrainReadsBack)"]
          why: '''On every BidirStd pad, from the pad's first attribute write on, the check compares the `virtual_od_en` bit of the read-back with the `virtual_od_en` bit of the pad's last attribute write. A BidirStd pad whose `virtual_od_en` reads 0 after a write of 1, or keeps an older value, fails it.'''
          milestone: "V2"
          priority: "2"
          security: false
          state: "open: not reviewed for this top"
        }
        {
          name: REQ_ATTR_06
          desc: '''The `od_en` field of every pad not of type BidirOd shall read back 0.'''
          source: [
            '''[Open drain / virtual open drain](hw/top_earlgrey/doc/design/README.md#open-drain--virtual-open-drain)'''
            '''[Pad Attributes](hw/top_darjeeling/ip_autogen/pinmux/doc/programmers_guide.md#pad-attributes)'''
            '''[top_darjeeling.hjson](hw/top_darjeeling/data/top_darjeeling.hjson)'''
          ]
          kind: "spec"
          testpoint: "pad_attr"
          checks: ["CHK_PAD_ATTR_05 no open drain elsewhere (assert_PadAttr_NoOpenDrainElsewhere)"]
          why: '''On every pad not of type BidirOd, the check compares the `od_en` bit of the read-back with 0 in every cycle, whatever software wrote. A pad of another type that stores and returns a written `od_en` bit fails it.'''
          milestone: "V2"
          priority: "2"
          security: false
          state: "open: not reviewed for this top"
        }
        {
          name: REQ_ATTR_07
          desc: '''The `virtual_od_en` field of every pad not of type BidirStd shall read back 0.'''
          source: [
            '''[Open drain / virtual open drain](hw/top_earlgrey/doc/design/README.md#open-drain--virtual-open-drain)'''
            '''[Pad Attributes](hw/top_darjeeling/ip_autogen/pinmux/doc/programmers_guide.md#pad-attributes)'''
            '''[top_darjeeling.hjson](hw/top_darjeeling/data/top_darjeeling.hjson)'''
          ]
          kind: "spec"
          testpoint: "pad_attr"
          checks: ["CHK_PAD_ATTR_06 no virtual open drain elsewhere (assert_PadAttr_NoVirtualOpenDrainElsewhere)"]
          why: '''On every pad not of type BidirStd, the check compares the `virtual_od_en` bit of the read-back with 0 in every cycle, whatever software wrote. A pad of another type that stores and returns a written `virtual_od_en` bit fails it.'''
          milestone: "V2"
          priority: "2"
          security: false
          state: "open: not reviewed for this top"
        }
        {
          name: REQ_ATTR_08c
          desc: '''The field `pull_en` shall read back as written where the pad's type keeps the field.'''
          source: [
            '''!!MIO_PAD_ATTR'''
            '''[Pad Attributes](hw/top_darjeeling/ip_autogen/pinmux/doc/programmers_guide.md#pad-attributes)'''
            '''[top_darjeeling.hjson](hw/top_darjeeling/data/top_darjeeling.hjson)'''
          ]
          kind: "spec"
          testpoint: "pad_attr"
          checks: ["CHK_PAD_ATTR_07 supported bits read back (assert_PadAttr_SupportedBitsReadBack)"]
          why: '''Per pad type the check requires the `pull_en` bit of the read-back to read 0 when written 0, and to read 1 for a write of 1 on every pad of the type once one pad of the type has done so. A kept bit that reads 1 after a write of 0, or 0 after a write of 1 in a later cycle or on another pad of the type, fails it.'''
          milestone: "V2"
          priority: "2"
          security: false
          state: "open: not reviewed for this top"
        }
        {
          name: REQ_ATTR_08d
          desc: '''The field `pull_select` shall read back as written where the pad's type keeps the field.'''
          source: [
            '''!!MIO_PAD_ATTR'''
            '''[Pad Attributes](hw/top_darjeeling/ip_autogen/pinmux/doc/programmers_guide.md#pad-attributes)'''
            '''[top_darjeeling.hjson](hw/top_darjeeling/data/top_darjeeling.hjson)'''
          ]
          kind: "spec"
          testpoint: "pad_attr"
          checks: ["CHK_PAD_ATTR_07 supported bits read back (assert_PadAttr_SupportedBitsReadBack)"]
          why: '''Per pad type the check requires the `pull_select` bit of the read-back to read 0 when written 0, and to read 1 for a write of 1 on every pad of the type once one pad of the type has done so. A kept bit that reads 1 after a write of 0, or 0 after a write of 1 in a later cycle or on another pad of the type, fails it.'''
          milestone: "V2"
          priority: "2"
          security: false
          state: "open: not reviewed for this top"
        }
        {
          name: REQ_ATTR_08e
          desc: '''The field `keeper_en` shall read back as written where the pad's type keeps the field.'''
          source: [
            '''!!MIO_PAD_ATTR'''
            '''[Pad Attributes](hw/top_darjeeling/ip_autogen/pinmux/doc/programmers_guide.md#pad-attributes)'''
            '''[top_darjeeling.hjson](hw/top_darjeeling/data/top_darjeeling.hjson)'''
          ]
          kind: "spec"
          testpoint: "pad_attr"
          checks: ["CHK_PAD_ATTR_07 supported bits read back (assert_PadAttr_SupportedBitsReadBack)"]
          why: '''Per pad type the check requires the `keeper_en` bit of the read-back to read 0 when written 0, and to read 1 for a write of 1 on every pad of the type once one pad of the type has done so. A kept bit that reads 1 after a write of 0, or 0 after a write of 1 in a later cycle or on another pad of the type, fails it.'''
          milestone: "V2"
          priority: "2"
          security: false
          state: "open: not reviewed for this top"
        }
        {
          name: REQ_ATTR_08f
          desc: '''The field `schmitt_en` shall read back as written where the pad's type keeps the field.'''
          source: [
            '''!!MIO_PAD_ATTR'''
            '''[Pad Attributes](hw/top_darjeeling/ip_autogen/pinmux/doc/programmers_guide.md#pad-attributes)'''
            '''[top_darjeeling.hjson](hw/top_darjeeling/data/top_darjeeling.hjson)'''
          ]
          kind: "spec"
          testpoint: "pad_attr"
          checks: ["CHK_PAD_ATTR_07 supported bits read back (assert_PadAttr_SupportedBitsReadBack)"]
          why: '''Per pad type the check requires the `schmitt_en` bit of the read-back to read 0 when written 0, and to read 1 for a write of 1 on every pad of the type once one pad of the type has done so. A kept bit that reads 1 after a write of 0, or 0 after a write of 1 in a later cycle or on another pad of the type, fails it.'''
          milestone: "V2"
          priority: "2"
          security: false
          state: "open: not reviewed for this top"
        }
        {
          name: REQ_ATTR_08g
          desc: '''The field `input_disable` shall read back as written where the pad's type keeps the field.'''
          source: [
            '''!!MIO_PAD_ATTR'''
            '''[Pad Attributes](hw/top_darjeeling/ip_autogen/pinmux/doc/programmers_guide.md#pad-attributes)'''
            '''[top_darjeeling.hjson](hw/top_darjeeling/data/top_darjeeling.hjson)'''
          ]
          kind: "spec"
          testpoint: "pad_attr"
          checks: ["CHK_PAD_ATTR_07 supported bits read back (assert_PadAttr_SupportedBitsReadBack)"]
          why: '''Per pad type the check requires the `input_disable` bit of the read-back to read 0 when written 0, and to read 1 for a write of 1 on every pad of the type once one pad of the type has done so. A kept bit that reads 1 after a write of 0, or 0 after a write of 1 in a later cycle or on another pad of the type, fails it.'''
          milestone: "V2"
          priority: "2"
          security: false
          state: "open: not reviewed for this top"
        }
        {
          name: REQ_ATTR_08h
          desc: '''Each bit of the field `slew_rate` shall read back as written where the pad's type keeps that bit.'''
          source: [
            '''!!MIO_PAD_ATTR'''
            '''[Pad Attributes](hw/top_darjeeling/ip_autogen/pinmux/doc/programmers_guide.md#pad-attributes)'''
            '''[top_darjeeling.hjson](hw/top_darjeeling/data/top_darjeeling.hjson)'''
          ]
          kind: "spec"
          testpoint: "pad_attr"
          checks: ["CHK_PAD_ATTR_07 supported bits read back (assert_PadAttr_SupportedBitsReadBack)"]
          why: '''Per pad type and per bit of `slew_rate`, the check requires the bit of the read-back to read 0 when written 0, and to read 1 for a write of 1 on every pad of the type once one pad of the type has done so. A kept bit that reads 1 after a write of 0, or 0 after a write of 1 in a later cycle or on another pad of the type, fails it.'''
          milestone: "V2"
          priority: "2"
          security: false
          state: "open: not reviewed for this top"
        }
        {
          name: REQ_ATTR_08i
          desc: '''Each bit of the field `drive_strength` shall read back as written where the pad's type keeps that bit.'''
          source: [
            '''!!MIO_PAD_ATTR'''
            '''[Pad Attributes](hw/top_darjeeling/ip_autogen/pinmux/doc/programmers_guide.md#pad-attributes)'''
            '''[top_darjeeling.hjson](hw/top_darjeeling/data/top_darjeeling.hjson)'''
          ]
          kind: "spec"
          testpoint: "pad_attr"
          checks: ["CHK_PAD_ATTR_07 supported bits read back (assert_PadAttr_SupportedBitsReadBack)"]
          why: '''Per pad type and per bit of `drive_strength`, the check requires the bit of the read-back to read 0 when written 0, and to read 1 for a write of 1 on every pad of the type once one pad of the type has done so. A kept bit that reads 1 after a write of 0, or 0 after a write of 1 in a later cycle or on another pad of the type, fails it.'''
          milestone: "V2"
          priority: "2"
          security: false
          state: "open: not reviewed for this top"
        }
        {
          name: REQ_ATTR_09c
          desc: '''The field `pull_en` shall read back 0 where the pad's type does not keep the field.'''
          source: [
            '''[Pad Attributes](hw/top_darjeeling/ip_autogen/pinmux/doc/programmers_guide.md#pad-attributes)'''
            '''[top_darjeeling.hjson](hw/top_darjeeling/data/top_darjeeling.hjson)'''
          ]
          kind: "spec"
          testpoint: "pad_attr"
          checks: ["CHK_PAD_ATTR_08 unsupported bits read 0 (assert_PadAttr_UnsupportedBitsRead0)"]
          why: '''Per pad type the check requires the `pull_en` bit of the read-back to read 0 when written 0, and to read 0 on every pad of the type, whatever is written, once a write of 1 has read 0 on one pad of the type. A bit not kept that reads 1 after a write of 0, or 1 after a write of 1 in a later cycle or on another pad of the type, fails it.'''
          milestone: "V2"
          priority: "2"
          security: false
          state: "open: not reviewed for this top"
        }
        {
          name: REQ_ATTR_09d
          desc: '''The field `pull_select` shall read back 0 where the pad's type does not keep the field.'''
          source: [
            '''[Pad Attributes](hw/top_darjeeling/ip_autogen/pinmux/doc/programmers_guide.md#pad-attributes)'''
            '''[top_darjeeling.hjson](hw/top_darjeeling/data/top_darjeeling.hjson)'''
          ]
          kind: "spec"
          testpoint: "pad_attr"
          checks: ["CHK_PAD_ATTR_08 unsupported bits read 0 (assert_PadAttr_UnsupportedBitsRead0)"]
          why: '''Per pad type the check requires the `pull_select` bit of the read-back to read 0 when written 0, and to read 0 on every pad of the type, whatever is written, once a write of 1 has read 0 on one pad of the type. A bit not kept that reads 1 after a write of 0, or 1 after a write of 1 in a later cycle or on another pad of the type, fails it.'''
          milestone: "V2"
          priority: "2"
          security: false
          state: "open: not reviewed for this top"
        }
        {
          name: REQ_ATTR_09e
          desc: '''The field `keeper_en` shall read back 0 where the pad's type does not keep the field.'''
          source: [
            '''[Pad Attributes](hw/top_darjeeling/ip_autogen/pinmux/doc/programmers_guide.md#pad-attributes)'''
            '''[top_darjeeling.hjson](hw/top_darjeeling/data/top_darjeeling.hjson)'''
          ]
          kind: "spec"
          testpoint: "pad_attr"
          checks: ["CHK_PAD_ATTR_08 unsupported bits read 0 (assert_PadAttr_UnsupportedBitsRead0)"]
          why: '''Per pad type the check requires the `keeper_en` bit of the read-back to read 0 when written 0, and to read 0 on every pad of the type, whatever is written, once a write of 1 has read 0 on one pad of the type. A bit not kept that reads 1 after a write of 0, or 1 after a write of 1 in a later cycle or on another pad of the type, fails it.'''
          milestone: "V2"
          priority: "2"
          security: false
          state: "open: not reviewed for this top"
        }
        {
          name: REQ_ATTR_09f
          desc: '''The field `schmitt_en` shall read back 0 where the pad's type does not keep the field.'''
          source: [
            '''[Pad Attributes](hw/top_darjeeling/ip_autogen/pinmux/doc/programmers_guide.md#pad-attributes)'''
            '''[top_darjeeling.hjson](hw/top_darjeeling/data/top_darjeeling.hjson)'''
          ]
          kind: "spec"
          testpoint: "pad_attr"
          checks: ["CHK_PAD_ATTR_08 unsupported bits read 0 (assert_PadAttr_UnsupportedBitsRead0)"]
          why: '''Per pad type the check requires the `schmitt_en` bit of the read-back to read 0 when written 0, and to read 0 on every pad of the type, whatever is written, once a write of 1 has read 0 on one pad of the type. A bit not kept that reads 1 after a write of 0, or 1 after a write of 1 in a later cycle or on another pad of the type, fails it.'''
          milestone: "V2"
          priority: "2"
          security: false
          state: "open: not reviewed for this top"
        }
        {
          name: REQ_ATTR_09g
          desc: '''The field `input_disable` shall read back 0 where the pad's type does not keep the field.'''
          source: [
            '''[Pad Attributes](hw/top_darjeeling/ip_autogen/pinmux/doc/programmers_guide.md#pad-attributes)'''
            '''[top_darjeeling.hjson](hw/top_darjeeling/data/top_darjeeling.hjson)'''
          ]
          kind: "spec"
          testpoint: "pad_attr"
          checks: ["CHK_PAD_ATTR_08 unsupported bits read 0 (assert_PadAttr_UnsupportedBitsRead0)"]
          why: '''Per pad type the check requires the `input_disable` bit of the read-back to read 0 when written 0, and to read 0 on every pad of the type, whatever is written, once a write of 1 has read 0 on one pad of the type. A bit not kept that reads 1 after a write of 0, or 1 after a write of 1 in a later cycle or on another pad of the type, fails it.'''
          milestone: "V2"
          priority: "2"
          security: false
          state: "open: not reviewed for this top"
        }
        {
          name: REQ_ATTR_09h
          desc: '''Each bit of the field `slew_rate` shall read back 0 where the pad's type does not keep that bit.'''
          source: [
            '''[Pad Attributes](hw/top_darjeeling/ip_autogen/pinmux/doc/programmers_guide.md#pad-attributes)'''
            '''[top_darjeeling.hjson](hw/top_darjeeling/data/top_darjeeling.hjson)'''
          ]
          kind: "spec"
          testpoint: "pad_attr"
          checks: ["CHK_PAD_ATTR_08 unsupported bits read 0 (assert_PadAttr_UnsupportedBitsRead0)"]
          why: '''Per pad type and per bit of `slew_rate`, the check requires the bit of the read-back to read 0 when written 0, and to read 0 on every pad of the type, whatever is written, once a write of 1 has read 0 on one pad of the type. A bit not kept that reads 1 after a write of 0, or 1 after a write of 1 in a later cycle or on another pad of the type, fails it.'''
          milestone: "V2"
          priority: "2"
          security: false
          state: "open: not reviewed for this top"
        }
        {
          name: REQ_ATTR_09i
          desc: '''Each bit of the field `drive_strength` shall read back 0 where the pad's type does not keep that bit.'''
          source: [
            '''[Pad Attributes](hw/top_darjeeling/ip_autogen/pinmux/doc/programmers_guide.md#pad-attributes)'''
            '''[top_darjeeling.hjson](hw/top_darjeeling/data/top_darjeeling.hjson)'''
          ]
          kind: "spec"
          testpoint: "pad_attr"
          checks: ["CHK_PAD_ATTR_08 unsupported bits read 0 (assert_PadAttr_UnsupportedBitsRead0)"]
          why: '''Per pad type and per bit of `drive_strength`, the check requires the bit of the read-back to read 0 when written 0, and to read 0 on every pad of the type, whatever is written, once a write of 1 has read 0 on one pad of the type. A bit not kept that reads 1 after a write of 0, or 1 after a write of 1 in a later cycle or on another pad of the type, fails it.'''
          milestone: "V2"
          priority: "2"
          security: false
          state: "open: not reviewed for this top"
        }
        {
          name: REQ_ATTR_10
          desc: '''After reset, every pad's attribute output shall be its reset value, with the fields its type does not keep at 0. Every field's reset value is 0, except the fields the `attrs` of the pad's entry in the top description set.'''
          source: [
            '''!!MIO_PAD_ATTR'''
            '''!!DIO_PAD_ATTR'''
            '''[top_darjeeling.hjson](hw/top_darjeeling/data/top_darjeeling.hjson)'''
            '''[top_darjeeling.hjson](hw/top_darjeeling/data/top_darjeeling.hjson)'''
            '''[top_darjeeling.hjson](hw/top_darjeeling/data/top_darjeeling.hjson)'''
          ]
          kind: "spec"
          testpoint: "pad_attr"
          checks: ["CHK_PAD_ATTR_09 reset attributes (assert_PadAttr_ResetAttributes)"]
          why: '''Not written for this top.'''
          milestone: "V2"
          priority: "2"
          security: false
          state: "open: not reviewed for this top"
        }
      ]
    }
    {
      name: '''Sleep retention'''
      conditions: [
        '''"pad" is MIO pad `p` or DIO pad `d`; "status bit" is its bit in `MIO_PAD_SLEEP_STATUS` or `DIO_PAD_SLEEP_STATUS`; "sleep entry" is a rise of `sleep_en_i`. The mode rows hold while no TAP owns the pad and the sleep mode is unchanged since sleep entry.'''
      ]
      requirements: [
        {
          name: REQ_SLP_01
          desc: '''At sleep entry, the status bit of every pad whose sleep enable is 1 shall become 1, unless a software clear of that bit lands in the same cycle (`REQ_SLP_09`).'''
          source: [
            '''!!MIO_PAD_SLEEP_EN.EN'''
            '''[Sleep Features](hw/top_darjeeling/ip_autogen/pinmux/doc/programmers_guide.md#sleep-features)'''
          ]
          kind: "spec"
          testpoint: "pad_sleep"
          checks: ["CHK_PAD_SLEEP_01 bit set at entry (assert_PadSleep_BitSetAtEntry)"]
          why: '''For every sleep entry with the pad's sleep enable at 1 and no software clear of its status bit, the check requires the bit to be 1 in the next cycle. A bit that stays 0, or rises a cycle late, fails it; a cycle with a clear is decided by _clear wins_ (CHK_PAD_SLEEP_05).'''
          milestone: "V2"
          priority: "2"
          security: false
          state: "open: not reviewed for this top"
        }
        {
          name: REQ_SLP_02
          desc: '''A status bit shall become 1 only at sleep entry, and only if the pad's sleep enable is 1.'''
          source: [
            '''!!MIO_PAD_SLEEP_STATUS.EN'''
            '''[Sleep Features](hw/top_darjeeling/ip_autogen/pinmux/doc/programmers_guide.md#sleep-features)'''
          ]
          kind: "spec"
          testpoint: "pad_sleep"
          checks: ["CHK_PAD_SLEEP_02 bit set only at entry (assert_PadSleep_BitSetOnlyAtEntry)"]
          why: '''For every rise of a status bit the check requires a sleep entry with the pad's sleep enable at 1 in the cycle before. A bit that rises with the enable at 0, without a rise of `sleep_en_i`, or while `sleep_en_i` merely stays high, fails it.'''
          milestone: "V2"
          priority: "2"
          security: false
          state: "open: not reviewed for this top"
        }
        {
          name: REQ_SLP_03a
          desc: '''While its status bit is 1 and its sleep mode is 0, a pad's output shall be 0.'''
          source: [
            '''!!MIO_PAD_SLEEP_MODE.OUT'''
            '''[Sleep Features](hw/top_darjeeling/ip_autogen/pinmux/doc/programmers_guide.md#sleep-features)'''
          ]
          kind: "spec"
          testpoint: "pad_sleep"
          checks: ["CHK_PAD_SLEEP_06 tie low in sleep (assert_PadSleep_TieLowInSleep)"]
          why: '''While the status bit is 1 and the mode taken at the entry is 0, the check compares the output of a pad no TAP owns with 0 in the same cycle. A pad that still carries its peripheral or its select's drive fails it.'''
          milestone: "V2"
          priority: "2"
          security: false
          state: "open: not reviewed for this top"
        }
        {
          name: REQ_SLP_03b
          desc: '''While its status bit is 1 and its sleep mode is 0, a pad's output enable shall be 1, so the pad drives 0.'''
          source: [
            '''!!MIO_PAD_SLEEP_MODE.OUT'''
            '''[Sleep Features](hw/top_darjeeling/ip_autogen/pinmux/doc/programmers_guide.md#sleep-features)'''
          ]
          kind: "spec"
          testpoint: "pad_sleep"
          checks: ["CHK_PAD_SLEEP_06 tie low in sleep (assert_PadSleep_TieLowInSleep)"]
          why: '''While held in mode 0, the check compares the output enable of a pad no TAP owns with 1. A pad left high-Z, or following its peripheral's enable, fails it.'''
          milestone: "V2"
          priority: "2"
          security: false
          state: "open: not reviewed for this top"
        }
        {
          name: REQ_SLP_04a
          desc: '''While its status bit is 1 and its sleep mode is 1, a pad's output shall be 1.'''
          source: [
            '''!!MIO_PAD_SLEEP_MODE.OUT'''
          ]
          kind: "spec"
          testpoint: "pad_sleep"
          checks: ["CHK_PAD_SLEEP_07 tie high in sleep (assert_PadSleep_TieHighInSleep)"]
          why: '''While the status bit is 1 and the mode taken at the entry is 1, the check compares the output of a pad no TAP owns with 1 in the same cycle. A pad that still carries its peripheral or its select's drive fails it.'''
          milestone: "V2"
          priority: "2"
          security: false
          state: "open: not reviewed for this top"
        }
        {
          name: REQ_SLP_04b
          desc: '''While its status bit is 1 and its sleep mode is 1, a pad's output enable shall be 1, so the pad drives 1.'''
          source: [
            '''!!MIO_PAD_SLEEP_MODE.OUT'''
          ]
          kind: "spec"
          testpoint: "pad_sleep"
          checks: ["CHK_PAD_SLEEP_07 tie high in sleep (assert_PadSleep_TieHighInSleep)"]
          why: '''While held in mode 1, the check compares the output enable of a pad no TAP owns with 1. A pad left high-Z, or following its peripheral's enable, fails it.'''
          milestone: "V2"
          priority: "2"
          security: false
          state: "open: not reviewed for this top"
        }
        {
          name: REQ_SLP_05a
          desc: '''While its status bit is 1 and its sleep mode is 2, a pad's output enable shall be 0: the pad is high-Z.'''
          source: [
            '''!!MIO_PAD_SLEEP_MODE.OUT'''
          ]
          kind: "spec"
          testpoint: "pad_sleep"
          checks: ["CHK_PAD_SLEEP_08 high-Z in sleep (assert_PadSleep_HighZInSleep)"]
          why: '''While the status bit is 1 and the mode taken at the entry is 2, the check compares the output enable of a pad no TAP owns with 0 in the same cycle. A pad that keeps driving in sleep fails it.'''
          milestone: "V2"
          priority: "2"
          security: false
          state: "open: not reviewed for this top"
        }
        {
          name: REQ_SLP_05b
          desc: '''While its status bit is 1 and its sleep mode is 2, a pad's output shall be 0.'''
          source: [
            '''!!MIO_PAD_SLEEP_MODE.OUT'''
          ]
          kind: "spec"
          testpoint: "pad_sleep"
          checks: ["CHK_PAD_SLEEP_08 high-Z in sleep (assert_PadSleep_HighZInSleep)"]
          why: '''While held in mode 2, the check compares the output of a pad no TAP owns with 0. A pad that leaves its peripheral's data or 1 on its output fails it.'''
          milestone: "V2"
          priority: "2"
          security: false
          state: "open: not reviewed for this top"
        }
        {
          name: REQ_SLP_06a
          desc: '''While its status bit is 1 and its sleep mode is 3, a pad shall keep the output it drove in the last cycle before the bit became 1.'''
          source: [
            '''!!MIO_PAD_SLEEP_MODE.OUT'''
            '''[Retention Logic](hw/top_darjeeling/ip_autogen/pinmux/doc/theory_of_operation.md#retention-logic)'''
          ]
          kind: "spec"
          testpoint: "pad_sleep"
          checks: ["CHK_PAD_SLEEP_09 keep holds (assert_PadSleep_KeepHolds)"]
          why: '''While the status bit is 1 and the mode taken at the entry is 3, the check compares the output of a pad no TAP owns with the output it drove in the last cycle before the bit became 1. A pad that follows its peripheral or its select, or keeps the value of another cycle, fails it. No specification states which output a JTAG pad that a TAP owned in that last cycle keeps, so the check claims none for it.'''
          milestone: "V2"
          priority: "2"
          security: false
          state: "open: not reviewed for this top"
        }
        {
          name: REQ_SLP_06b
          desc: '''While its status bit is 1 and its sleep mode is 3, a pad shall keep the output enable it drove in the last cycle before the bit became 1.'''
          source: [
            '''!!MIO_PAD_SLEEP_MODE.OUT'''
            '''[Retention Logic](hw/top_darjeeling/ip_autogen/pinmux/doc/theory_of_operation.md#retention-logic)'''
          ]
          kind: "spec"
          testpoint: "pad_sleep"
          checks: ["CHK_PAD_SLEEP_09 keep holds (assert_PadSleep_KeepHolds)"]
          why: '''While held in mode 3, the check compares the output enable of a pad no TAP owns with the one it drove in the last cycle before the bit became 1. A pad that turns high-Z after driving, or starts to drive after being high-Z, fails it. No specification states which enable a JTAG pad that a TAP owned in that last cycle keeps, so the check claims none for it.'''
          milestone: "V2"
          priority: "2"
          security: false
          state: "open: not reviewed for this top"
        }
        {
          name: REQ_SLP_07
          desc: '''Once 1, a status bit shall stay 1 until software writes 0 to it, whatever `sleep_en_i`, the sleep enable and the peripheral do.'''
          source: [
            '''!!MIO_PAD_SLEEP_STATUS.EN'''
            '''[Retention Logic](hw/top_darjeeling/ip_autogen/pinmux/doc/theory_of_operation.md#retention-logic)'''
          ]
          kind: "spec"
          testpoint: "pad_sleep"
          checks: ["CHK_PAD_SLEEP_03 bit holds until cleared (assert_PadSleep_BitHoldsUntilCleared)", "CHK_PAD_SLEEP_04 clear releases (assert_PadSleep_ClearReleases)"]
          why: '''The check _bit holds until cleared_ (CHK_PAD_SLEEP_03) requires a bit at 1 to be 1 in the next cycle unless software clears it, whatever `sleep_en_i`, the sleep enable and the peripherals do; a bit that falls when sleep ends, or on a write of 1, fails it. The check _clear releases_ (CHK_PAD_SLEEP_04) requires a software clear to give 0 in the next cycle, so the bit ends at the clear and not later.'''
          milestone: "V2"
          priority: "2"
          security: false
          state: "open: not reviewed for this top"
        }
        {
          name: REQ_SLP_08
          desc: '''While its status bit is 0, a pad shall drive what it drives awake: an MIO pad what its output select names, a DIO pad the output and output enable of its own peripheral.'''
          source: [
            '''[Retention Logic](hw/top_darjeeling/ip_autogen/pinmux/doc/theory_of_operation.md#retention-logic)'''
            '''[Sleep Features](hw/top_darjeeling/ip_autogen/pinmux/doc/programmers_guide.md#sleep-features)'''
          ]
          kind: "spec"
          testpoint: "sleep_release"
          checks: ["CHK_PAD_OUTPUT_01 tie 0 drives 0 (assert_PadOutput_Tie0Drives0)", "CHK_PAD_OUTPUT_02 tie 1 drives 1 (assert_PadOutput_Tie1Drives1)", "CHK_PAD_OUTPUT_03 select 2 is high-Z (assert_PadOutput_Select2IsHighZ)", "CHK_PAD_OUTPUT_04 drives selected output (assert_PadOutput_DrivesSelectedOutput)", "CHK_PAD_OUTPUT_05 no output is high-Z (assert_PadOutput_NoOutputIsHighZ)", "CHK_PAD_OUTPUT_06 DIO drives its peripheral (assert_PadOutput_DIODrivesItsPeripheral)"]
          why: '''Each holds in every cycle the pad is awake, its status bit at 0, whether the bit was never set or was cleared; together they cover every select and every DIO pad. A pad that still drives the value of its sleep mode in a cycle its bit reads 0 fails the check of its select; a JTAG pad a TAP owns is decided by the JTAG pad checks.'''
          milestone: "V2"
          priority: "2"
          security: false
          state: "open: not reviewed for this top"
        }
        {
          name: REQ_SLP_09
          desc: '''When sleep entry sets a status bit in the cycle software writes 0 to that bit, the bit shall end 0: software's clear wins.'''
          source: [
            '''!!MIO_PAD_SLEEP_STATUS'''
            '''[Type RW](util/reggen/README.md#type-rw)'''
            '''[Simultaneous SW and HW access](util/reggen/README.md#simultaneous-sw-and-hw-access)'''
          ]
          kind: "spec"
          testpoint: "pad_sleep"
          checks: ["CHK_PAD_SLEEP_05 clear wins (assert_PadSleep_ClearWins)"]
          why: '''For a cycle with both a sleep entry, the pad's sleep enable at 1, and a software clear of the bit, the check requires the bit to be 0 in the next cycle. A design that lets the hardware set win fails it.'''
          milestone: "V2"
          priority: "2"
          security: false
          state: "open: not reviewed for this top"
        }
        {
          name: REQ_SLP_10a
          desc: '''A write to a pad's sleep mode while its status bit is 1 shall leave the pad as it is.'''
          source: [
            '''[Retention Logic](hw/top_darjeeling/ip_autogen/pinmux/doc/theory_of_operation.md#retention-logic)'''
            '''[Sleep Features](hw/top_darjeeling/ip_autogen/pinmux/doc/programmers_guide.md#sleep-features)'''
          ]
          kind: "spec"
          testpoint: "pad_sleep"
          checks: ["CHK_PAD_SLEEP_10 mode write while held (assert_PadSleep_ModeWriteWhileHeld)"]
          why: '''After a write to the sleep mode while the bit is 1, the check requires the pad to keep driving the sleep value of the mode taken at the entry. A design that applies the new mode at once changes the pad's drive and fails it.'''
          milestone: "V2"
          priority: "2"
          security: false
          state: "open: not reviewed for this top"
        }
        {
          name: REQ_SLP_10b
          desc: '''After a write to a pad's sleep mode while its status bit is 1, the new mode shall act at the next sleep entry.'''
          source: [
            '''[Retention Logic](hw/top_darjeeling/ip_autogen/pinmux/doc/theory_of_operation.md#retention-logic)'''
            '''[Sleep Features](hw/top_darjeeling/ip_autogen/pinmux/doc/programmers_guide.md#sleep-features)'''
          ]
          kind: "spec"
          testpoint: "pad_sleep"
          checks: ["CHK_PAD_SLEEP_06 tie low in sleep (assert_PadSleep_TieLowInSleep)", "CHK_PAD_SLEEP_07 tie high in sleep (assert_PadSleep_TieHighInSleep)", "CHK_PAD_SLEEP_08 high-Z in sleep (assert_PadSleep_HighZInSleep)", "CHK_PAD_SLEEP_09 keep holds (assert_PadSleep_KeepHolds)"]
          why: '''Each of the four sleep mode checks compares a held pad's drive with the sleep value of the mode the register held at the sleep entry that set its bit, so after a release the next entry takes the mode written while held. A design that keeps the old mode, or never takes the new one, drives the wrong sleep value and fails one of them. That the register holds the written mode is checked by the generated register checker.'''
          milestone: "V2"
          priority: "2"
          security: false
          state: "open: not reviewed for this top"
        }
      ]
    }
    {
      name: '''Register locks'''
      conditions: [
        '''"lock" is one bit of a `*_REGWEN` register; it locks the registers of the same index. The rule that a locked pad's attributes do not change (`REQ_LOCK_03a`, `REQ_LOCK_03b`) holds except on a JTAG pad while a TAP owns it.'''
      ]
      requirements: [
        {
          name: REQ_LOCK_01a
          desc: '''Every lock shall read 1 after reset.'''
          source: [
            '''the register description: the `EN` field of each `*_REGWEN`, e.g. !!MIO_PAD_ATTR_REGWEN.EN `resval: "1"`, on `clk_i` with `rst_ni` ([pinmux.hjson `clocking`](hw/top_darjeeling/ip_autogen/pinmux/data/pinmux.hjson))'''
            '''[Configuration and Register Definition File Format](util/reggen/README.md#configuration-and-register-definition-file-format)'''
          ]
          kind: "spec"
          testpoint: "fpv_csr_rw"
          checks: ["the generated CSR checker"]
          why: '''After reset the generated register checker expects every lock at its reset value 1, bit 31 of `ALERT_TEST` included, and compares each lock's value and read with it; a lock that leaves reset at 0 fails the first compare.'''
          milestone: "V2"
          priority: "2"
          security: true
          state: "open: not reviewed for this top"
        }
        {
          name: REQ_LOCK_01b
          desc: '''Once software writes 0 to a lock, the lock shall stay 0 until reset.'''
          source: [
            '''[Configuration and Register Definition File Format](util/reggen/README.md#configuration-and-register-definition-file-format)'''
            '''[Pad Attributes](hw/top_darjeeling/ip_autogen/pinmux/doc/programmers_guide.md#pad-attributes)'''
          ]
          kind: "spec"
          testpoint: "fpv_csr_rw"
          checks: ["the generated CSR checker"]
          why: '''The generated register checker predicts each lock as `rw0c`: an accepted write of 0 clears it and nothing sets it; a lock that returns to 1 before a reset fails the compare.'''
          milestone: "V2"
          priority: "2"
          security: true
          state: "open: not reviewed for this top"
        }
        {
          name: REQ_LOCK_01c
          desc: '''A write of 1 to a lock that is 0 shall not reopen it.'''
          source: [
            '''the register description: each lock `rw0c`'''
            '''[Configuration and Register Definition File Format](util/reggen/README.md#configuration-and-register-definition-file-format)'''
            '''[Pinmux Configuration](hw/top_darjeeling/ip_autogen/pinmux/doc/programmers_guide.md#pinmux-configuration)'''
          ]
          kind: "spec"
          testpoint: "fpv_csr_rw"
          checks: ["the generated CSR checker"]
          why: '''The generated register checker predicts each lock as `rw0c`, which keeps a closed lock at 0 over a write of 1; a lock that such a write reopens fails the compare.'''
          milestone: "V2"
          priority: "2"
          security: true
          state: "open: not reviewed for this top"
        }
        {
          name: REQ_LOCK_02
          desc: '''While a lock is 0, a write to a register it locks shall leave that register unchanged.'''
          source: [
            '''!!MIO_PERIPH_INSEL_REGWEN.EN'''
            '''[Configuration and Register Definition File Format](util/reggen/README.md#configuration-and-register-definition-file-format)'''
          ]
          kind: "spec"
          testpoint: "fpv_csr_rw"
          checks: ["CHK_REGWEN_02 locked read-back holds (assert_Regwen_LockedReadBackHolds)"]
          why: '''The generated register checker holds each register whose lock reads 0 over every write to it; a register that takes such a write fails it. The attribute registers, whose value the pinmux supplies, are decided by _locked read-back holds_ (CHK_REGWEN_02) on every pad, a JTAG pad a TAP owns included: a locked attribute register whose read-back changes fails it.'''
          milestone: "V2"
          priority: "2"
          security: true
          state: "open: not reviewed for this top"
        }
        {
          name: REQ_LOCK_03a
          desc: '''While a pad's attribute lock is 0, its attribute output shall not change.'''
          source: [
            '''!!MIO_PAD_ATTR_REGWEN.EN'''
            '''[Pad Attributes](hw/top_darjeeling/ip_autogen/pinmux/doc/programmers_guide.md#pad-attributes)'''
          ]
          kind: "spec"
          testpoint: "regwen"
          checks: ["CHK_REGWEN_01 locked attribute holds (assert_Regwen_LockedAttributeHolds)"]
          why: '''It compares the pad's attribute output in each cycle its lock is 0 with the output in the next cycle, on a pad that is not a JTAG pad a TAP owns. Any change, from a write or from anything else, fails it.'''
          milestone: "V2"
          priority: "2"
          security: true
          state: "open: not reviewed for this top"
        }
        {
          name: REQ_LOCK_03b
          desc: '''While a pad's attribute lock is 0, what its attribute register reads back shall not change.'''
          source: [
            '''!!MIO_PAD_ATTR_REGWEN.EN'''
            '''[Pad Attributes](hw/top_darjeeling/ip_autogen/pinmux/doc/programmers_guide.md#pad-attributes)'''
          ]
          kind: "spec"
          testpoint: "regwen"
          checks: ["CHK_REGWEN_02 locked read-back holds (assert_Regwen_LockedReadBackHolds)"]
          why: '''It compares what the pad's attribute register reads back in each cycle its lock is 0 with the read-back in the next cycle, on every pad, a JTAG pad a TAP owns included. A locked register that takes a write, whole or in part, fails it.'''
          milestone: "V2"
          priority: "2"
          security: true
          state: "open: not reviewed for this top"
        }
      ]
    }
    {
      name: '''Register block and bus'''
      conditions: [
        '''a "failed request" is a request whose command integrity code does not match, or a write whose data integrity code does not match ([Usage of User Bits](hw/ip/tlul/README.md#usage-of-user-bits): the data code covers "the write data"). A read whose only mismatch is in its data code is not a failed request, and no row checks its response or its alert. The "in-band reset" is the alert handler's re-initialization, during which it puts a signal integrity error on its ping and acknowledge pairs on purpose ([Employed Solution](hw/top_earlgrey/ip_autogen/alert_handler/doc/theory_of_operation.md#employed-solution)). The sender's answer to it, a signal integrity error on `alert_tx_o` and then a return to idle ([Employed Solution](hw/top_earlgrey/ip_autogen/alert_handler/doc/theory_of_operation.md#employed-solution)), has no row: the sender is the shared primitive `prim_alert_sender` (`rtl/pinmux.sv`:143-147), whose own upstream FPV drives the in-band reset and checks the return to idle (`hw/ip/prim/fpv/tb/prim_alert_rxtx_*`, `InBandInitFromReceiverToSender_A`). The alert rows read `alert_tx_o`, with an alert handler. An "illegal combination of address, size and mask" is a request whose address, size and mask do not correspond as TileLink requires (TileLink 1.9.3 p. 49-51: "a_size, a_address and a_mask are required to correspond with one another"): an address not aligned to its size (p. 51: "a_address must be aligned to a_size"), a size above 2, a mask bit set on a byte lane outside the access, or a `PutFullData` whose mask leaves a lane of the access 0. [Explicit Error Cases](hw/ip/tlul/README.md#explicit-error-cases) lists the last three "for example"; the unaligned address is verification's reading.'''
      ]
      requirements: [
        {
          name: REQ_REG_01a
          desc: '''Every register field shall take software's reads and writes as the access type of its register description entry says, for every request not answered with an error and, for a write, while the lock of its register reads 1 or it has no lock.'''
          source: [
            '''the register description: each field's `swaccess`, e.g. !!MIO_PAD_SLEEP_STATUS `swaccess: "rw0c"`'''
            '''[Configuration and Register Definition File Format](util/reggen/README.md#configuration-and-register-definition-file-format)'''
          ]
          kind: "spec"
          testpoint: "fpv_csr_rw"
          checks: ["CHK_PAD_ATTR_10 read-back changes only on a write (assert_PadAttr_ReadBackChangesOnlyOnAWrite)"]
          why: '''The generated register checker predicts each field from its access type and each request whose integrity codes are correct, and compares the field and every read with it; a field that takes a write its type or a closed lock refuses fails it. The attribute registers keep no value of their own (the pinmux supplies it), so their storage is decided by _read-back changes only on a write_ (CHK_PAD_ATTR_10): a read-back that changes with no accepted write to the pad's attribute register before it fails it. A write refused for its integrity code and the hardware set of a sleep status bit are left to the pinmux's own bus and sleep checks.'''
          milestone: "V2"
          priority: "2"
          security: true
          state: "open: not reviewed for this top"
        }
        {
          name: REQ_REG_01b
          desc: '''Every register field shall read its register description reset value after reset.'''
          source: [
            '''the register description: each field's `resval`, e.g. !!MIO_PAD_SLEEP_STATUS.EN `resval: "0"`'''
            '''[Configuration and Register Definition File Format](util/reggen/README.md#configuration-and-register-definition-file-format)'''
          ]
          kind: "spec"
          testpoint: "fpv_csr_rw"
          checks: ["the generated CSR checker"]
          why: '''After reset the generated register checker expects each field at its reset value; a field that leaves reset with another value fails the first compare. The attribute registers, whose value the pinmux supplies, are left to _reset attributes_ (CHK_PAD_ATTR_09).'''
          milestone: "V2"
          priority: "2"
          security: true
          state: "open: not reviewed for this top"
        }
        {
          name: REQ_BUS_01a
          desc: '''The pinmux shall answer every request with one response, and only one.'''
          source: [
            '''TileLink 1.9.3 p. 39: "Receipt of request messages must result in the eventual receipt of a response message by the requestor."; p. 30: "it is illegal to receive a response without receiving the request."; p. 46: "In TL-UL, every message fits within a single beat"'''
          ]
          kind: "spec"
          testpoint: "bus"
          checks: ["CHK_BUS_01 device rules (assert_Bus_DeviceRules)"]
          why: '''The TL-UL VIP's device rules match each response on the pinmux's port to an open request. A request left without a response, or a second response to one request, fails them.'''
          milestone: "V2"
          priority: "2"
          security: true
          state: "open: not reviewed for this top"
        }
        {
          name: REQ_BUS_01b
          desc: '''The pinmux shall answer every request by the TL-UL rules with a response that carries the request's source ID.'''
          source: [
            '''[Source ID requirements for device elements](hw/ip/tlul/README.md#source-id-requirements-for-device-elements)'''
          ]
          kind: "spec"
          testpoint: "bus"
          checks: ["CHK_BUS_01 device rules (assert_Bus_DeviceRules)"]
          why: '''The TL-UL VIP's device rules hold every response to the TL-UL handshake and compare its `d_source` with its request's `a_source`. A response that carries another source ID fails them.'''
          milestone: "V2"
          priority: "2"
          security: true
          state: "open: not reviewed for this top"
        }
        {
          name: REQ_BUS_01c
          desc: '''The pinmux shall answer with an error only a request that fails its integrity check, has an undefined opcode, has an illegal combination of address, size and mask, is a write of 8 or 16 bits not aligned to a word, is a write narrower than its register, or targets an address no register maps; a read whose only mismatch is in its data integrity code may get either answer.'''
          source: [
            '''[Explicit Error Cases](hw/ip/tlul/README.md#explicit-error-cases)'''
            '''[Error responses](util/reggen/README.md#error-responses)'''
          ]
          kind: "spec"
          testpoint: "bus"
          checks: ["CHK_BUS_02 errors as the register checker predicts"]
          why: '''It requires `d_error` 1 on a request that is not a failed request exactly when one of the listed causes holds, as the generated register checker's error checks predict; a read whose only fault is its data integrity code may get either answer, so the check leaves it out. A good request answered with an error fails it; a failed request is a listed cause, so its error never does.'''
          milestone: "V2"
          priority: "2"
          security: true
          state: "open: not reviewed for this top"
        }
        {
          name: REQ_BUS_02a
          desc: '''Every response shall carry the response integrity code over its op code, size and error.'''
          source: [
            '''[Usage of User Bits](hw/ip/tlul/README.md#usage-of-user-bits)'''
            '''[pinmux.hjson `countermeasures` BUS.INTEGRITY](hw/top_darjeeling/ip_autogen/pinmux/data/pinmux.hjson)'''
          ]
          kind: "spec"
          testpoint: "bus"
          checks: ["CHK_BUS_03 response codes correct (assert_Bus_ResponseCodesCorrect)"]
          why: '''It recomputes the response code from each response's opcode, size and error with the encoder both ends of the link share, and compares it with the code sent. A code over other fields, or a stale one, fails it.'''
          milestone: "V2"
          priority: "2"
          security: true
          state: "open: not reviewed for this top"
        }
        {
          name: REQ_BUS_02b
          desc: '''Every response shall carry the data integrity code over its data.'''
          source: [
            '''[Usage of User Bits](hw/ip/tlul/README.md#usage-of-user-bits)'''
            '''[pinmux.hjson `countermeasures` BUS.INTEGRITY](hw/top_darjeeling/ip_autogen/pinmux/data/pinmux.hjson)'''
          ]
          kind: "spec"
          testpoint: "bus"
          checks: ["CHK_BUS_03 response codes correct (assert_Bus_ResponseCodesCorrect)"]
          why: '''It recomputes the data code over each response's data with the encoder both ends of the link share, and compares it with the code sent. A code computed over other data fails it.'''
          milestone: "V2"
          priority: "2"
          security: true
          state: "open: not reviewed for this top"
        }
        {
          name: REQ_BUS_03
          desc: '''A failed request shall get an error response.'''
          source: [
            '''[Usage of User Bits](hw/ip/tlul/README.md#usage-of-user-bits)'''
            '''[cip_base_vseq](hw/dv/sv/cip_lib/README.md#cip_base_vseq)'''
          ]
          kind: "RTL"
          testpoint: "bus"
          checks: ["CHK_BUS_04 failed request errors (assert_Bus_FailedRequestErrors)"]
          why: '''It requires `d_error` 1 on the response to every failed request: a bad command code, or a write with a bad data code. A design that answers a tampered request as a good one fails it.'''
          milestone: "V2"
          priority: "2"
          security: true
          state: "open: not reviewed for this top"
        }
        {
          name: REQ_BUS_04
          desc: '''A failed write shall change no register.'''
          source: [
            '''[Usage of User Bits](hw/ip/tlul/README.md#usage-of-user-bits)'''
          ]
          kind: "RTL"
          testpoint: "bus"
          checks: ["CHK_BUS_05 failed write changes nothing (assert_Bus_FailedWriteChangesNothing)"]
          why: '''It holds every register over a failed write, the attribute registers by their read-back; a status bit takes only its hardware set. An AON field with an earlier write still crossing is left to _no change without a write_ (CHK_WAKEUP_SYNC_02), which lets it take only that write; a failed write that lands fails one of the two.'''
          milestone: "V2"
          priority: "2"
          security: true
          state: "open: not reviewed for this top"
        }
        {
          name: REQ_BUS_05
          desc: '''Outside the alert handler's in-band reset, a failed request shall raise the fatal alert `fatal_fault`.'''
          source: [
            '''[pinmux.hjson `alert_list` fatal_fault](hw/top_darjeeling/ip_autogen/pinmux/data/pinmux.hjson)'''
            '''[Employed Solution](hw/top_earlgrey/ip_autogen/alert_handler/doc/theory_of_operation.md#employed-solution)'''
          ]
          kind: "spec"
          testpoint: "alert"
          checks: ["CHK_ALERT_01 failed request alerts (assert_Alert_FailedRequestAlerts)"]
          why: '''It requires an alert event on `alert_tx_o` within 40 cycles of every failed request, the alert handler answering by the alert protocol. A design that ignores a tampered request, or alerts late, fails it.'''
          milestone: "V2S"
          priority: "2"
          security: true
          state: "open: not reviewed for this top"
        }
        {
          name: REQ_BUS_06
          desc: '''Outside the alert handler's in-band reset, once raised, the fatal alert shall be sent again and again until reset.'''
          source: [
            '''[Alerts per Module](doc/contributing/hw/comportability/README.md#alerts-per-module)'''
            '''[Employed Solution](hw/top_earlgrey/ip_autogen/alert_handler/doc/theory_of_operation.md#employed-solution)'''
          ]
          kind: "spec"
          testpoint: "alert"
          checks: ["CHK_ALERT_02 fatal alert repeats (assert_Alert_FatalAlertRepeats)"]
          why: '''After a failed request it requires an alert event within 40 cycles of every cycle, until reset. A sender that stops after one event, or after the handler's answer, fails it.'''
          milestone: "V2S"
          priority: "2"
          security: true
          state: "open: not reviewed for this top"
        }
        {
          name: REQ_BUS_07
          desc: '''Outside the alert handler's in-band reset, a write of 1 to `ALERT_TEST` bit 0 not answered with an error, while its bit 31 is 1, shall send one alert event.'''
          source: [
            '''`doc/registers.md`:668: "Write 1 to trigger one alert event of this kind."'''
            '''[Test Alert Register Creation](doc/contributing/hw/comportability/README.md#test-alert-register-creation)'''
            '''[Employed Solution](hw/top_earlgrey/ip_autogen/alert_handler/doc/theory_of_operation.md#employed-solution)'''
          ]
          kind: "spec"
          testpoint: "alert"
          checks: ["CHK_ALERT_03 test sends an event (assert_Alert_TestSendsAnEvent)", "CHK_ALERT_04 no alert without a cause (assert_Alert_NoAlertWithoutACause)"]
          why: '''The check _test sends an event_ (CHK_ALERT_03) requires each alert test's credit to be used up by an alert event within 40 cycles; _no alert without a cause_ (CHK_ALERT_04) lets each event use up one credit, so one test gives one event. A lost test fails _test sends an event_, and a second event for one test fails _no alert without a cause_.'''
          milestone: "V2S"
          priority: "2"
          security: true
          state: "open: not reviewed for this top"
        }
        {
          name: REQ_BUS_08
          desc: '''Outside the alert handler's in-band reset, while `ALERT_TEST` bit 31 is 0, a write to its bit 0 that is not a failed request shall send no alert.'''
          source: [
            '''`doc/registers.md`:666: "Write 0 to disable alert testing until the next reset."'''
            '''[Employed Solution](hw/top_earlgrey/ip_autogen/alert_handler/doc/theory_of_operation.md#employed-solution)'''
          ]
          kind: "spec"
          testpoint: "alert"
          checks: ["CHK_ALERT_04 no alert without a cause (assert_Alert_NoAlertWithoutACause)"]
          why: '''A write of bit 0 while bit 31 of `ALERT_TEST` is 0 sets no test credit, so an alert event that follows it with no other cause finds no credit and fails the check. After a read whose only fault is its data integrity code, which may raise the alert or not, the check claims nothing until reset.'''
          milestone: "V2S"
          priority: "2"
          security: true
          state: "open: not reviewed for this top"
        }
        {
          name: REQ_BUS_09
          desc: '''Outside the alert handler's in-band reset and apart from answering a ping, the fatal alert shall be sent only after a failed request or an alert test; a read whose only mismatch is in its data integrity code may raise it or not.'''
          source: [
            '''[pinmux.hjson `alert_list` fatal_fault](hw/top_darjeeling/ip_autogen/pinmux/data/pinmux.hjson)'''
            '''[Employed Solution](hw/top_earlgrey/ip_autogen/alert_handler/doc/theory_of_operation.md#employed-solution)'''
          ]
          kind: "spec"
          testpoint: "alert"
          checks: ["CHK_ALERT_04 no alert without a cause (assert_Alert_NoAlertWithoutACause)"]
          why: '''It allows an alert event only after a failed request since reset, or against a ping or test credit, each event using up one credit and a ping's credit lapsing 40 cycles after its ping. An event with no failed request, test or ping behind it fails the check. After a read whose only fault is its data integrity code, which may raise the alert or not, the check claims nothing until reset.'''
          milestone: "V2S"
          priority: "2"
          security: true
          state: "open: not reviewed for this top"
        }
        {
          name: REQ_BUS_10a
          desc: '''A request with an *undefined opcode* shall get an error response.'''
          source: [
            '''[Usage of Opcode, Size and Mask](hw/ip/tlul/README.md#usage-of-opcode-size-and-mask)'''
            '''[Error responses](util/reggen/README.md#error-responses)'''
          ]
          kind: "spec"
          testpoint: "bus"
          checks: ["CHK_BUS_02 errors as the register checker predicts"]
          why: '''The generated register checker's error checks require `d_error` 1 on a request with an undefined opcode, and an error only for a listed cause. A block that serves such a request, or refuses a good one, fails them; the run leaves opcodes free.'''
          milestone: "V2"
          priority: "2"
          security: true
          state: "open: not reviewed for this top"
        }
        {
          name: REQ_BUS_10b
          desc: '''A request with an *illegal combination of address, size and mask*, as the Scope above defines it, shall get an error response.'''
          source: [
            '''[Explicit Error Cases](hw/ip/tlul/README.md#explicit-error-cases)'''
            '''TileLink 1.9.3 p. 51: "a_address must be aligned to a_size."'''
          ]
          kind: "spec"
          testpoint: "bus"
          checks: ["CHK_BUS_02 errors as the register checker predicts"]
          why: '''The generated register checker's error checks require `d_error` 1 on a request with a size above 2, a lane outside the access, a full write with a lane at 0, or an address not aligned to its size. Masks are contiguous in the run, so the checker's either-way rule for a non-contiguous mask never applies; a block that answers such a request without an error fails them.'''
          milestone: "V2"
          priority: "2"
          security: true
          state: "open: not reviewed for this top"
        }
        {
          name: REQ_BUS_10c
          desc: '''A *write of 8 or 16 bits to an address not aligned to a word* shall get an error response.'''
          source: [
            '''[Error responses](util/reggen/README.md#error-responses)'''
            '''[Explicit Error Cases](hw/ip/tlul/README.md#explicit-error-cases)'''
          ]
          kind: "spec"
          testpoint: "bus"
          checks: ["CHK_BUS_02 errors as the register checker predicts"]
          why: '''The generated register checker's error checks require `d_error` 1 on an 8 or 16 bit write to an address not aligned to a word. A block that answers such a write without an error fails them.'''
          milestone: "V2"
          priority: "2"
          security: true
          state: "open: not reviewed for this top"
        }
        {
          name: REQ_BUS_10d
          desc: '''A *write narrower than its register*, whose width the location of its fields sets, shall get an error response.'''
          source: [
            '''[Error responses](util/reggen/README.md#error-responses)'''
          ]
          kind: "spec"
          testpoint: "bus"
          checks: ["CHK_BUS_02 errors as the register checker predicts"]
          why: '''The generated register checker's error checks require `d_error` 1 on a write narrower than its register, the register's width set by its fields in the register description. A block that answers such a write without an error fails them.'''
          milestone: "V2"
          priority: "2"
          security: true
          state: "open: not reviewed for this top"
        }
        {
          name: REQ_BUS_10e
          desc: '''A request to an *address no register maps*, within the address bits the register block decodes, shall get an error response.'''
          source: [
            '''[Explicit Error Cases](hw/ip/tlul/README.md#explicit-error-cases)'''
            '''[Error responses](util/reggen/README.md#error-responses)'''
          ]
          kind: "spec"
          testpoint: "bus"
          checks: ["CHK_BUS_02 errors as the register checker predicts"]
          why: '''The generated register checker's error checks require `d_error` 1 on a request to an address within the decoded bits that no register maps. A block that answers such a request without an error fails them.'''
          milestone: "V2"
          priority: "2"
          security: true
          state: "open: not reviewed for this top"
        }
        {
          name: REQ_BUS_11
          desc: '''A write answered with an error for any reason other than a failed integrity check shall change no register.'''
          source: [
            '''[cip_base_vseq](hw/dv/sv/cip_lib/README.md#cip_base_vseq)'''
            '''[Error responses](util/reggen/README.md#error-responses)'''
          ]
          kind: "spec"
          testpoint: "bus"
          checks: ["CHK_BUS_06 error write changes nothing"]
          why: '''It holds every register over a write answered with an error: the generated register checker the stored fields, _read-back changes only on a write_ (CHK_PAD_ATTR_10) the attribute registers it leaves out (`hwext`), and _no change without a write_ (CHK_WAKEUP_SYNC_02) and _no clear without a write_ (CHK_WAKEUP_SYNC_04) the AON fields and cause bits. A block that lets such a write land fails one of them.'''
          milestone: "V2"
          priority: "2"
          security: true
          state: "open: not reviewed for this top"
        }
      ]
    }
    {
      name: '''Wakeup detectors'''
      conditions: [
        '''`w` is a detector (0 to 7); a cycle is a `clk_aon_i` cycle (watched signal, forwarded value: terms).'''
        '''Register values are those the AON logic holds once a write has crossed.'''
        '''The rows hold with scan mode not True.'''
        '''They hold with the mode unchanged while enabled; the other fields may change while enabled.'''
        '''They hold whatever `sleep_en_i` does.'''
        '''They hold whatever `clk_i` does, stopped included: in sleep "only the wakeup detector logic will be actively clocked" ([Retention and Wakeup Features](hw/top_darjeeling/ip_autogen/pinmux/doc/theory_of_operation.md#retention-and-wakeup-features)).'''
        '''They are checked from the filter's fourth sample after `rst_aon_ni`.'''
        '''The timed rows (`REQ_WKUP_09a` to `REQ_WKUP_10b`) hold for `CNT_TH` 1 and above: no spec says what a timed detector does with 0, the reset value.'''
      ]
      requirements: [
        {
          name: REQ_WKUP_01
          desc: '''With `MIODIO` 0, the watched signal shall be MIO pad `PADSEL` - 2 for `PADSEL` 2 to 13, and the constant 0 or 1 for `PADSEL` 0 or 1.'''
          source: [
            '''!!MIO_PERIPH_INSEL.IN'''
            '''!!WKUP_DETECTOR.MIODIO'''
            '''!!WKUP_DETECTOR_PADSEL.SEL'''
            '''[Retention and Wakeup Features](hw/top_darjeeling/ip_autogen/pinmux/doc/theory_of_operation.md#retention-and-wakeup-features)'''
            '''[Wakeup Detectors](hw/top_darjeeling/ip_autogen/pinmux/doc/theory_of_operation.md#wakeup-detectors)'''
            '''[top_darjeeling_pinmux.ipconfig.hjson `n_mio_pads`](hw/top_darjeeling/ip_autogen/pinmux/data/top_darjeeling_pinmux.ipconfig.hjson)'''
          ]
          kind: "spec"
          testpoint: "wakeup"
          checks: ["CHK_WAKEUP_03 edge sets cause (assert_Wakeup_EdgeSetsCause)", "CHK_WAKEUP_04 timed high sets cause (assert_Wakeup_TimedHighSetsCause)", "CHK_WAKEUP_05 timed low sets cause (assert_Wakeup_TimedLowSetsCause)", "CHK_WAKEUP_06 no false cause (assert_Wakeup_NoFalseCause)"]
          why: '''The checks read the pattern on the forwarded value of the MIO pad or constant the select names: a detector on another pad misses this pad's edge or fires on the other's, and a constant read at the wrong level misses a timed detection or makes a false one.'''
          milestone: "V2"
          priority: "1"
          security: false
          state: "open: not reviewed for this top"
        }
        {
          name: REQ_WKUP_02
          desc: '''With `MIODIO` 1, the watched signal shall be DIO pad `PADSEL` for `PADSEL` 0 to 72.'''
          source: [
            '''!!WKUP_DETECTOR.MIODIO'''
            '''!!WKUP_DETECTOR_PADSEL.SEL'''
            '''[MIO and DIO Signal Categories](hw/top_darjeeling/ip_autogen/pinmux/doc/theory_of_operation.md#mio-and-dio-signal-categories)'''
            '''[top_darjeeling_pinmux.ipconfig.hjson `n_dio_pads`](hw/top_darjeeling/ip_autogen/pinmux/data/top_darjeeling_pinmux.ipconfig.hjson)'''
          ]
          kind: "spec"
          testpoint: "wakeup"
          checks: ["CHK_WAKEUP_03 edge sets cause (assert_Wakeup_EdgeSetsCause)", "CHK_WAKEUP_06 no false cause (assert_Wakeup_NoFalseCause)"]
          why: '''The checks read the pattern on the forwarded value of the DIO pad the select names: a detector on another pad misses an edge of this one or fires on an edge of the other.'''
          milestone: "V2"
          priority: "1"
          security: false
          state: "open: not reviewed for this top"
        }
        {
          name: REQ_WKUP_03
          desc: '''A `PADSEL` that names no pad (14 to 127 with `MIODIO` 0, 73 to 127 with `MIODIO` 1) shall give the watched signal 0.'''
          source: [
            '''!!WKUP_DETECTOR_PADSEL.SEL'''
            '''[top_darjeeling_pinmux.ipconfig.hjson `n_mio_pads`, `n_dio_pads`](hw/top_darjeeling/ip_autogen/pinmux/data/top_darjeeling_pinmux.ipconfig.hjson)'''
          ]
          kind: "spec"
          testpoint: "wakeup"
          checks: ["CHK_WAKEUP_05 timed low sets cause (assert_Wakeup_TimedLowSetsCause)", "CHK_WAKEUP_06 no false cause (assert_Wakeup_NoFalseCause)"]
          why: '''A select that names no pad watches 0: in mode 4 a detector that reads 1 never fires, and one that reads a pad fires on its edges or its level 1, which no pattern of 0 answers.'''
          milestone: "V2"
          priority: "1"
          security: false
          state: "open: not reviewed for this top"
        }
        {
          name: REQ_WKUP_04
          desc: '''With `FILTER` 0, the forwarded value shall be the watched signal as sampled at each `clk_aon_i` edge.'''
          source: [
            '''[Wakeup Detectors](hw/top_darjeeling/ip_autogen/pinmux/doc/theory_of_operation.md#wakeup-detectors)'''
          ]
          kind: "spec"
          testpoint: "wakeup"
          checks: ["CHK_WAKEUP_03 edge sets cause (assert_Wakeup_EdgeSetsCause)", "CHK_WAKEUP_06 no false cause (assert_Wakeup_NoFalseCause)"]
          why: '''With `FILTER` 0 the forwarded value is the pad as sampled: a detector that drops a sample misses an edge, and one that sees a level the pad never had fires with no pattern; a delay of up to 4 cycles is allowed.'''
          milestone: "V2"
          priority: "1"
          security: false
          state: "open: not reviewed for this top"
        }
        {
          name: REQ_WKUP_05
          desc: '''With `FILTER` 1, the forwarded value shall take a new value only once 4 samples in a row have had it.'''
          source: [
            '''!!WKUP_DETECTOR.FILTER'''
          ]
          kind: "spec"
          testpoint: "wakeup"
          checks: ["CHK_WAKEUP_03 edge sets cause (assert_Wakeup_EdgeSetsCause)", "CHK_WAKEUP_06 no false cause (assert_Wakeup_NoFalseCause)"]
          why: '''A level held for 4 samples is an edge of the forwarded value and a 3-sample glitch is none: a filter that needs more samples misses the 4-sample level, and one that needs fewer fires on the glitch.'''
          milestone: "V2"
          priority: "1"
          security: false
          state: "open: not reviewed for this top"
        }
        {
          name: REQ_WKUP_06a
          desc: '''An enabled detector in mode 0 (Posedge) shall detect every rise of the forwarded value.'''
          source: [
            '''!!WKUP_DETECTOR.MODE'''
            '''[Wakeup Detectors](hw/top_darjeeling/ip_autogen/pinmux/doc/theory_of_operation.md#wakeup-detectors)'''
          ]
          kind: "spec"
          testpoint: "wakeup"
          checks: ["CHK_WAKEUP_01 posedge sets cause (assert_Wakeup_PosedgeSetsCause)"]
          why: '''It wants a hardware write of 1 to bit `w` of `WKUP_CAUSE` within 8 cycles of each rise of the forwarded value at which `EN` is 1 and stays 1 for 4 more cycles: a detector that misses a rise, a one-sample pulse included, fails it.'''
          milestone: "V2"
          priority: "1"
          security: false
          state: "open: not reviewed for this top"
        }
        {
          name: REQ_WKUP_06b
          desc: '''An enabled detector in mode 0 (Posedge) shall detect only at a rise of the forwarded value.'''
          source: [
            '''!!WKUP_DETECTOR.MODE'''
            '''[Wakeup Detectors](hw/top_darjeeling/ip_autogen/pinmux/doc/theory_of_operation.md#wakeup-detectors)'''
          ]
          kind: "spec"
          testpoint: "wakeup"
          checks: ["CHK_WAKEUP_06 no false cause (assert_Wakeup_NoFalseCause)"]
          why: '''In mode 0 it refuses a hardware write of 1 to a cause bit at 0 that no rise of the forwarded value, seen up to 4 cycles late with `EN` 1, answers: a detector that also fires on a fall fails it.'''
          milestone: "V2"
          priority: "1"
          security: false
          state: "open: not reviewed for this top"
        }
        {
          name: REQ_WKUP_07a
          desc: '''An enabled detector in mode 1 (Negedge) shall detect every fall of the forwarded value.'''
          source: [
            '''!!WKUP_DETECTOR.MODE'''
          ]
          kind: "spec"
          testpoint: "wakeup"
          checks: ["CHK_WAKEUP_02 negedge sets cause (assert_Wakeup_NegedgeSetsCause)"]
          why: '''It wants a hardware write of 1 to bit `w` of `WKUP_CAUSE` within 8 cycles of each fall of the forwarded value at which `EN` is 1 and stays 1 for 4 more cycles: a detector that misses a fall fails it.'''
          milestone: "V2"
          priority: "1"
          security: false
          state: "open: not reviewed for this top"
        }
        {
          name: REQ_WKUP_07b
          desc: '''An enabled detector in mode 1 (Negedge) shall detect only at a fall of the forwarded value.'''
          source: [
            '''!!WKUP_DETECTOR.MODE'''
          ]
          kind: "spec"
          testpoint: "wakeup"
          checks: ["CHK_WAKEUP_06 no false cause (assert_Wakeup_NoFalseCause)"]
          why: '''In mode 1 it refuses a hardware write of 1 to a cause bit at 0 that no fall of the forwarded value answers: a detector that fires on a rise fails it.'''
          milestone: "V2"
          priority: "1"
          security: false
          state: "open: not reviewed for this top"
        }
        {
          name: REQ_WKUP_08a
          desc: '''An enabled detector in mode 2 (Edge) shall detect every change of the forwarded value.'''
          source: [
            '''!!WKUP_DETECTOR.MODE'''
          ]
          kind: "spec"
          testpoint: "wakeup"
          checks: ["CHK_WAKEUP_03 edge sets cause (assert_Wakeup_EdgeSetsCause)"]
          why: '''It wants a hardware write of 1 to bit `w` of `WKUP_CAUSE` within 8 cycles of each rise and each fall of the forwarded value at which `EN` is 1 and stays 1 for 4 more cycles: a detector that sees only one direction fails it.'''
          milestone: "V2"
          priority: "1"
          security: false
          state: "open: not reviewed for this top"
        }
        {
          name: REQ_WKUP_08b
          desc: '''An enabled detector in mode 2 (Edge) shall detect only at a change of the forwarded value.'''
          source: [
            '''!!WKUP_DETECTOR.MODE'''
          ]
          kind: "spec"
          testpoint: "wakeup"
          checks: ["CHK_WAKEUP_06 no false cause (assert_Wakeup_NoFalseCause)"]
          why: '''In mode 2 it refuses a hardware write of 1 to a cause bit at 0 that no rise or fall of the forwarded value answers: a detector that fires on a steady pad fails it.'''
          milestone: "V2"
          priority: "1"
          security: false
          state: "open: not reviewed for this top"
        }
        {
          name: REQ_WKUP_09a
          desc: '''An enabled detector in mode 3 (TimedHigh) shall detect when the forwarded value has been 1 for `CNT_TH` cycles in a row.'''
          source: [
            '''!!WKUP_DETECTOR.MODE'''
            '''!!WKUP_DETECTOR_CNT_TH.TH'''
            '''[Wakeup Detectors](hw/top_darjeeling/ip_autogen/pinmux/doc/theory_of_operation.md#wakeup-detectors)'''
            '''[top_darjeeling_pinmux.ipconfig.hjson `wkup_cnt_width`](hw/top_darjeeling/ip_autogen/pinmux/data/top_darjeeling_pinmux.ipconfig.hjson)'''
          ]
          kind: "spec"
          testpoint: "wakeup"
          checks: ["CHK_WAKEUP_04 timed high sets cause (assert_Wakeup_TimedHighSetsCause)"]
          why: '''It counts the cycles in a row with `EN` 1 and the forwarded value 1, and asks for a hardware write of 1 to the cause bit within 8 cycles once the count reaches `CNT_TH` + 1, the later of the two counts, `CNT_TH` or `CNT_TH` + 1, that the specification's wording allows: a detector that never fires, or fires later, fails it. It makes no claim on a level that began while `EN` was 0, as no specification says whether those cycles count.'''
          milestone: "V2"
          priority: "1"
          security: false
          state: "open: not reviewed for this top"
        }
        {
          name: REQ_WKUP_09b
          desc: '''An enabled detector in mode 3 (TimedHigh) shall *never detect* while the forwarded value has been 1 for fewer than `CNT_TH` cycles in a row.'''
          source: [
            '''!!WKUP_DETECTOR.MODE'''
            '''[top_darjeeling_pinmux.ipconfig.hjson `wkup_cnt_width`](hw/top_darjeeling/ip_autogen/pinmux/data/top_darjeeling_pinmux.ipconfig.hjson)'''
          ]
          kind: "spec"
          testpoint: "wakeup"
          checks: ["CHK_WAKEUP_06 no false cause (assert_Wakeup_NoFalseCause)"]
          why: '''In mode 3 it refuses a hardware write of 1 to the cause bit while the forwarded value has been 1 for fewer than `CNT_TH` cycles in a row with `EN` 1: a detector that fires early fails it. It makes no claim on a level that began while `EN` was 0, as no specification says whether those cycles count.'''
          milestone: "V2"
          priority: "1"
          security: false
          state: "open: not reviewed for this top"
        }
        {
          name: REQ_WKUP_10a
          desc: '''An enabled detector in mode 4 (TimedLow) shall detect when the forwarded value has been 0 for `CNT_TH` cycles in a row.'''
          source: [
            '''!!WKUP_DETECTOR.MODE'''
            '''!!WKUP_DETECTOR_CNT_TH.TH'''
            '''[Wakeup Detectors](hw/top_darjeeling/ip_autogen/pinmux/doc/theory_of_operation.md#wakeup-detectors)'''
            '''[top_darjeeling_pinmux.ipconfig.hjson `wkup_cnt_width`](hw/top_darjeeling/ip_autogen/pinmux/data/top_darjeeling_pinmux.ipconfig.hjson)'''
          ]
          kind: "spec"
          testpoint: "wakeup"
          checks: ["CHK_WAKEUP_05 timed low sets cause (assert_Wakeup_TimedLowSetsCause)"]
          why: '''It counts the cycles in a row with `EN` 1 and the forwarded value 0, and asks for a hardware write of 1 to the cause bit within 8 cycles once the count reaches `CNT_TH` + 1, the later of the two counts, `CNT_TH` or `CNT_TH` + 1, that the specification's wording allows: a detector that never fires, or fires later, fails it. It makes no claim on a level that began while `EN` was 0, as no specification says whether those cycles count.'''
          milestone: "V2"
          priority: "1"
          security: false
          state: "open: not reviewed for this top"
        }
        {
          name: REQ_WKUP_10b
          desc: '''An enabled detector in mode 4 (TimedLow) shall *never detect* while the forwarded value has been 0 for fewer than `CNT_TH` cycles in a row.'''
          source: [
            '''!!WKUP_DETECTOR.MODE'''
            '''[top_darjeeling_pinmux.ipconfig.hjson `wkup_cnt_width`](hw/top_darjeeling/ip_autogen/pinmux/data/top_darjeeling_pinmux.ipconfig.hjson)'''
          ]
          kind: "spec"
          testpoint: "wakeup"
          checks: ["CHK_WAKEUP_06 no false cause (assert_Wakeup_NoFalseCause)"]
          why: '''In mode 4 it refuses a hardware write of 1 to the cause bit while the forwarded value has been 0 for fewer than `CNT_TH` cycles in a row with `EN` 1: a detector that fires early fails it. It makes no claim on a level that began while `EN` was 0, as no specification says whether those cycles count.'''
          milestone: "V2"
          priority: "1"
          security: false
          state: "open: not reviewed for this top"
        }
        {
          name: REQ_WKUP_11
          desc: '''An enabled detector in mode 5, 6 or 7 shall detect exactly the rises of the forwarded value, as in mode 0 (Posedge).'''
          source: [
            '''!!WKUP_DETECTOR.MODE'''
          ]
          kind: "spec"
          testpoint: "wakeup"
          checks: ["CHK_WAKEUP_01 posedge sets cause (assert_Wakeup_PosedgeSetsCause)", "CHK_WAKEUP_06 no false cause (assert_Wakeup_NoFalseCause)"]
          why: '''Both checks read `MODE` 5, 6 and 7 as mode 0: a detector there that misses a rise fails _posedge sets cause_ (CHK_WAKEUP_01), and one that fires on a fall or a level fails _no false cause_ (CHK_WAKEUP_06).'''
          milestone: "V2"
          priority: "1"
          security: false
          state: "open: not reviewed for this top"
        }
        {
          name: REQ_WKUP_12
          desc: '''A detector whose enable is 0 shall detect nothing.'''
          source: [
            '''!!WKUP_DETECTOR_EN.EN'''
          ]
          kind: "spec"
          testpoint: "wakeup"
          checks: ["CHK_WAKEUP_06 no false cause (assert_Wakeup_NoFalseCause)"]
          why: '''It refuses a hardware write of 1 to a cause bit at 0 that no pattern seen with `EN` 1 answers: a disabled detector that fires on its pattern fails it. An edge within 4 cycles of an enable change may set the bit or not.'''
          milestone: "V2"
          priority: "1"
          security: false
          state: "open: not reviewed for this top"
        }
        {
          name: REQ_WKUP_13a
          desc: '''The sampling shall run while the detector is disabled, so that enabling the detector does not restart it.'''
          source: [
            '''None: the theory of operation and the register description are silent'''
          ]
          kind: "RTL"
          testpoint: "wakeup"
          checks: ["CHK_WAKEUP_06 no false cause (assert_Wakeup_NoFalseCause)", "CHK_WAKEUP_01 posedge sets cause (assert_Wakeup_PosedgeSetsCause)"]
          why: '''The checks sample the pad whatever `EN` is, so a pad steady at 1 before the enable is no rise: a detector whose sampling restarts at the enable sees one and sets the cause bit, which _no false cause_ (CHK_WAKEUP_06) refuses. The check _posedge sets cause_ (CHK_WAKEUP_01) wants a rise that completes just after the enable to be detected.'''
          milestone: "V2"
          priority: "1"
          security: false
          state: "open: not reviewed for this top"
        }
        {
          name: REQ_WKUP_13b
          desc: '''The filter shall run while the detector is disabled, so that enabling the detector does not restart it.'''
          source: [
            '''None: the theory of operation and the register description are silent'''
          ]
          kind: "RTL"
          testpoint: "wakeup"
          checks: ["CHK_WAKEUP_06 no false cause (assert_Wakeup_NoFalseCause)", "CHK_WAKEUP_01 posedge sets cause (assert_Wakeup_PosedgeSetsCause)"]
          why: '''The checks' filter counts samples whatever `EN` is: a filter that restarts at the enable turns a pad steady at 1 into a new rise and sets the cause bit, which _no false cause_ (CHK_WAKEUP_06) refuses. The check _posedge sets cause_ (CHK_WAKEUP_01) wants a rise whose 4 samples span the enable to be detected.'''
          milestone: "V2"
          priority: "1"
          security: false
          state: "open: not reviewed for this top"
        }
        {
          name: REQ_WKUP_14
          desc: '''When an enabled detector detects, bit `w` of `WKUP_CAUSE` shall become 1.'''
          source: [
            '''[Wakeup Detectors](hw/top_darjeeling/ip_autogen/pinmux/doc/theory_of_operation.md#wakeup-detectors)'''
            '''!!WKUP_CAUSE.CAUSE'''
            '''[Wakeup Features](hw/top_darjeeling/ip_autogen/pinmux/doc/programmers_guide.md#wakeup-features)'''
            '''[top_darjeeling_pinmux.ipconfig.hjson `n_wkup_detect`](hw/top_darjeeling/ip_autogen/pinmux/data/top_darjeeling_pinmux.ipconfig.hjson)'''
          ]
          kind: "spec"
          testpoint: "wakeup"
          checks: ["CHK_WAKEUP_01 posedge sets cause (assert_Wakeup_PosedgeSetsCause)", "CHK_WAKEUP_02 negedge sets cause (assert_Wakeup_NegedgeSetsCause)", "CHK_WAKEUP_03 edge sets cause (assert_Wakeup_EdgeSetsCause)", "CHK_WAKEUP_04 timed high sets cause (assert_Wakeup_TimedHighSetsCause)", "CHK_WAKEUP_05 timed low sets cause (assert_Wakeup_TimedLowSetsCause)", "CHK_WAKEUP_07 set lands (assert_Wakeup_SetLands)"]
          why: '''The five mode checks (CHK_WAKEUP_01 to CHK_WAKEUP_05) want a hardware write of 1 to bit `w` within 8 cycles of each detection, and _set lands_ (CHK_WAKEUP_07) wants the bit 1 in the next cycle: a detection that never reaches bit `w`, or reaches another bit, fails them. A set in the cycle software's clear of the bit lands ends 0, as `REQ_WKUP_17` says.'''
          milestone: "V2"
          priority: "1"
          security: false
          state: "open: not reviewed for this top"
        }
        {
          name: REQ_WKUP_15
          desc: '''Bit `w` of `WKUP_CAUSE` shall become 1 only when detector `w` detects.'''
          source: [
            '''!!WKUP_CAUSE.CAUSE'''
            '''[top_darjeeling_pinmux.ipconfig.hjson `n_wkup_detect`](hw/top_darjeeling/ip_autogen/pinmux/data/top_darjeeling_pinmux.ipconfig.hjson)'''
          ]
          kind: "spec"
          testpoint: "wakeup"
          checks: ["CHK_WAKEUP_06 no false cause (assert_Wakeup_NoFalseCause)", "CHK_WAKEUP_08 cause rises only on a set (assert_Wakeup_CauseRisesOnlyOnASet)"]
          why: '''The check _no false cause_ (CHK_WAKEUP_06) refuses a hardware write of 1 to bit `w` at 0 that no pattern of detector `w` answers, and _cause rises only on a set_ (CHK_WAKEUP_08) refuses a rise of bit `w` with no such write in the cycle before: a set with no detection, a detection wired to another bit, or a bit raised by a software write of 1 fails one of them.'''
          milestone: "V2"
          priority: "1"
          security: false
          state: "open: not reviewed for this top"
        }
        {
          name: REQ_WKUP_16
          desc: '''Once 1, a cause bit shall stay 1 until software's clear of it lands, whatever the detector, its enable and the pad do.'''
          source: [
            '''!!WKUP_CAUSE'''
            '''!!WKUP_CAUSE.CAUSE'''
            '''[Wakeup Features](hw/top_darjeeling/ip_autogen/pinmux/doc/programmers_guide.md#wakeup-features)'''
            '''[Wakeup Recording](hw/top_darjeeling/ip_autogen/pwrmgr/doc/theory_of_operation.md#wakeup-recording)'''
          ]
          kind: "spec"
          testpoint: "wakeup_cause"
          checks: ["CHK_WAKEUP_CAUSE_02 cause holds until cleared (assert_WakeupCause_CauseHoldsUntilCleared)", "CHK_WAKEUP_CAUSE_01 hardware only sets cause (assert_WakeupCause_HardwareOnlySetsCause)"]
          why: '''The check _cause holds until cleared_ (CHK_WAKEUP_CAUSE_02) allows a fall of the bit only in the cycle after software's clear of it lands or at `rst_aon_ni`, and _hardware only sets cause_ (CHK_WAKEUP_CAUSE_01) refuses a hardware write of 0 to the bit at 1 with no clear landing. A bit dropped when its detector is disabled, changes mode or sees its pad change fails _cause holds until cleared_, and _hardware only sets cause_ too when hardware writes the 0.'''
          milestone: "V2"
          priority: "2"
          security: false
          state: "open: not reviewed for this top"
        }
        {
          name: REQ_WKUP_17
          desc: '''When a detection sets a cause bit in the cycle software's clear of it lands, the bit shall end 0: software's clear wins.'''
          source: [
            '''!!WKUP_CAUSE'''
            '''[Type RW](util/reggen/README.md#type-rw)'''
            '''[Simultaneous SW and HW access](util/reggen/README.md#simultaneous-sw-and-hw-access)'''
          ]
          kind: "spec"
          testpoint: "wakeup_cause"
          checks: ["CHK_WAKEUP_CAUSE_03 set and clear together (assert_WakeupCause_SetAndClearTogether)"]
          why: '''It takes every cycle in which a hardware write of 1 to a cause bit meets software's clear of the same bit landing, and wants the bit 0 in the next cycle: a register that lets the set win keeps the bit at 1 and fails it.'''
          milestone: "V2"
          priority: "2"
          security: false
          state: "open: not reviewed for this top"
        }
        {
          name: REQ_WKUP_18a
          desc: '''`pin_wkup_req_o` shall be 1 while at least one cause bit is 1.'''
          source: [
            '''[Inter-Module Signals](hw/top_darjeeling/ip_autogen/pinmux/doc/interfaces.md#inter-module-signals)'''
            '''[Wakeup Detectors](hw/top_darjeeling/ip_autogen/pinmux/doc/theory_of_operation.md#wakeup-detectors)'''
            '''[Wakeup Recording](hw/top_darjeeling/ip_autogen/pwrmgr/doc/theory_of_operation.md#wakeup-recording)'''
            '''[top_darjeeling_pinmux.ipconfig.hjson `n_wkup_detect`](hw/top_darjeeling/ip_autogen/pinmux/data/top_darjeeling_pinmux.ipconfig.hjson)'''
          ]
          kind: "spec"
          testpoint: "wakeup_cause"
          checks: ["CHK_WAKEUP_CAUSE_04 request follows cause (assert_WakeupCause_RequestFollowsCause)"]
          why: '''It wants `pin_wkup_req_o` 1 within 2 cycles of any cause bit rising, and 1 while any cause bit has held 1 for 3 cycles in a row: a request that leaves out one of the eight bits, or drops while a bit is still 1, fails it.'''
          milestone: "V2"
          priority: "2"
          security: false
          state: "open: not reviewed for this top"
        }
        {
          name: REQ_WKUP_18b
          desc: '''`pin_wkup_req_o` shall be 0 while every cause bit is 0.'''
          source: [
            '''[Inter-Module Signals](hw/top_darjeeling/ip_autogen/pinmux/doc/interfaces.md#inter-module-signals)'''
            '''[Wakeup Detectors](hw/top_darjeeling/ip_autogen/pinmux/doc/theory_of_operation.md#wakeup-detectors)'''
            '''[Wakeup Recording](hw/top_darjeeling/ip_autogen/pwrmgr/doc/theory_of_operation.md#wakeup-recording)'''
            '''[top_darjeeling_pinmux.ipconfig.hjson `n_wkup_detect`](hw/top_darjeeling/ip_autogen/pinmux/data/top_darjeeling_pinmux.ipconfig.hjson)'''
          ]
          kind: "spec"
          testpoint: "wakeup_cause"
          checks: ["CHK_WAKEUP_CAUSE_05 no request without cause (assert_WakeupCause_NoRequestWithoutCause)"]
          why: '''It wants `pin_wkup_req_o` 0 once every cause bit has been 0 for 3 cycles in a row: a request that stays 1 after the last bit is cleared, or rises on a pattern that set no bit, fails it.'''
          milestone: "V2"
          priority: "2"
          security: false
          state: "open: not reviewed for this top"
        }
        {
          name: REQ_WKUP_19a
          desc: '''A write to a detector's enable shall reach the AON logic within a bounded time.'''
          source: [
            '''!!WKUP_DETECTOR_EN'''
            '''!!WKUP_DETECTOR'''
            '''!!WKUP_DETECTOR_CNT_TH'''
            '''!!WKUP_CAUSE'''
            '''[Wakeup Features](hw/top_darjeeling/ip_autogen/pinmux/doc/programmers_guide.md#wakeup-features)'''
          ]
          kind: "spec"
          testpoint: "wakeup_sync"
          checks: ["CHK_WAKEUP_SYNC_01 write lands (assert_WakeupSync_WriteLands)", "CHK_WAKEUP_SYNC_02 no change without a write (assert_WakeupSync_NoChangeWithoutAWrite)"]
          why: '''For `EN`, _write lands_ (CHK_WAKEUP_SYNC_01) wants the AON copy to hold the written value within 4 cycles of each write accepted with its lock open, until the next one lands, and _no change without a write_ (CHK_WAKEUP_SYNC_02) allows a change only to a written value not yet landed. An enable write lost, late or landing another value fails _write lands_; a change no write explains fails _no change without a write_.'''
          milestone: "V2"
          priority: "2"
          security: false
          state: "open: not reviewed for this top"
        }
        {
          name: REQ_WKUP_19b
          desc: '''A write to a detector's configuration shall reach the AON logic within a bounded time.'''
          source: [
            '''!!WKUP_DETECTOR_EN'''
            '''!!WKUP_DETECTOR'''
            '''!!WKUP_DETECTOR_CNT_TH'''
            '''!!WKUP_CAUSE'''
            '''[Wakeup Features](hw/top_darjeeling/ip_autogen/pinmux/doc/programmers_guide.md#wakeup-features)'''
          ]
          kind: "spec"
          testpoint: "wakeup_sync"
          checks: ["CHK_WAKEUP_SYNC_01 write lands (assert_WakeupSync_WriteLands)", "CHK_WAKEUP_SYNC_02 no change without a write (assert_WakeupSync_NoChangeWithoutAWrite)"]
          why: '''For `MODE`, `FILTER` and `MIODIO`, each its own field, _write lands_ (CHK_WAKEUP_SYNC_01) wants the AON copy to hold the written value within 4 cycles of each write accepted with its lock open, until the next one lands, and _no change without a write_ (CHK_WAKEUP_SYNC_02) allows a change only to a written value not yet landed. A configuration write lost, late or landing another value fails _write lands_; a field that changes with no write behind it fails _no change without a write_.'''
          milestone: "V2"
          priority: "2"
          security: false
          state: "open: not reviewed for this top"
        }
        {
          name: REQ_WKUP_19c
          desc: '''A write to a detector's threshold shall reach the AON logic within a bounded time.'''
          source: [
            '''!!WKUP_DETECTOR_EN'''
            '''!!WKUP_DETECTOR'''
            '''!!WKUP_DETECTOR_CNT_TH'''
            '''!!WKUP_CAUSE'''
            '''[Wakeup Features](hw/top_darjeeling/ip_autogen/pinmux/doc/programmers_guide.md#wakeup-features)'''
          ]
          kind: "spec"
          testpoint: "wakeup_sync"
          checks: ["CHK_WAKEUP_SYNC_01 write lands (assert_WakeupSync_WriteLands)", "CHK_WAKEUP_SYNC_02 no change without a write (assert_WakeupSync_NoChangeWithoutAWrite)"]
          why: '''For `CNT_TH`, _write lands_ (CHK_WAKEUP_SYNC_01) wants the AON copy to hold the written value within 4 cycles of each write accepted with its lock open, until the next one lands, and _no change without a write_ (CHK_WAKEUP_SYNC_02) allows a change only to a written value not yet landed. A threshold write lost, late or landing another value fails _write lands_; a threshold that changes with no write behind it fails _no change without a write_.'''
          milestone: "V2"
          priority: "2"
          security: false
          state: "open: not reviewed for this top"
        }
        {
          name: REQ_WKUP_19d
          desc: '''A clear of `WKUP_CAUSE` shall reach the AON logic within a bounded time.'''
          source: [
            '''!!WKUP_DETECTOR_EN'''
            '''!!WKUP_DETECTOR'''
            '''!!WKUP_DETECTOR_CNT_TH'''
            '''!!WKUP_CAUSE'''
            '''[Wakeup Features](hw/top_darjeeling/ip_autogen/pinmux/doc/programmers_guide.md#wakeup-features)'''
          ]
          kind: "spec"
          testpoint: "wakeup_sync"
          checks: ["CHK_WAKEUP_SYNC_03 clear lands (assert_WakeupSync_ClearLands)", "CHK_WAKEUP_SYNC_05 landed clear clears cause (assert_WakeupSync_LandedClearClearsCause)", "CHK_WAKEUP_SYNC_04 no clear without a write (assert_WakeupSync_NoClearWithoutAWrite)"]
          why: '''The check _clear lands_ (CHK_WAKEUP_SYNC_03) wants each software clear of bit `w` of `WKUP_CAUSE` to land in the AON logic within 10 cycles, _landed clear clears cause_ (CHK_WAKEUP_SYNC_05) wants the bit 0 in the cycle after it lands, and _no clear without a write_ (CHK_WAKEUP_SYNC_04) refuses a clear landing with no software clear behind it. A clear lost, late or landing without effect fails _clear lands_ or _landed clear clears cause_; a write of 1 that clears fails _no clear without a write_.'''
          milestone: "V2"
          priority: "2"
          security: false
          state: "open: not reviewed for this top"
        }
        {
          name: REQ_WKUP_20a
          desc: '''A write to a detector's *configuration* accepted before a write to its enable shall hold in the AON logic no later than that enable write.'''
          source: [
            '''!!WKUP_DETECTOR_EN'''
          ]
          kind: "spec"
          testpoint: "wakeup_sync"
          checks: ["CHK_WAKEUP_SYNC_06 writes land in order (assert_WakeupSync_WritesLandInOrder)"]
          why: '''It compares the AON cycles in which a configuration write and a later enable write land: an enable that holds before the configuration fails it.'''
          milestone: "V2"
          priority: "2"
          security: false
          state: "open: not reviewed for this top"
        }
        {
          name: REQ_WKUP_20b
          desc: '''A write to a detector's *threshold* accepted before a write to its enable shall hold in the AON logic no later than that enable write.'''
          source: [
            '''!!WKUP_DETECTOR_EN'''
          ]
          kind: "spec"
          testpoint: "wakeup_sync"
          checks: ["CHK_WAKEUP_SYNC_06 writes land in order (assert_WakeupSync_WritesLandInOrder)"]
          why: '''It compares the AON cycles in which a threshold write and a later enable write land: an enable that holds before the threshold fails it.'''
          milestone: "V2"
          priority: "2"
          security: false
          state: "open: not reviewed for this top"
        }
      ]
    }
  ]
}
